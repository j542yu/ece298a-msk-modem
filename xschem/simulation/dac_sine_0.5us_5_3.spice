* Automatically generated DAC stimulus: sine
* DAC bits: 8
* Number of code intervals: 256
* Dwell: 5e-07 s
* Edge duration: 1e-09 s
* Simulation duration: 0.000128 s

V10 B_5_3[0] GND PWL(0 0 1.499e-06 0 1.5e-06 3.3 1.999e-06 3.3 2e-06 0 5.999e-06 0 6e-06 3.3 6.499e-06 3.3 6.5e-06 0 6.999e-06 0 7e-06 3.3 7.499e-06 3.3 7.5e-06 0 7.999e-06 0 8e-06 3.3 8.499e-06 3.3 8.5e-06 0 8.999e-06 0 9e-06 3.3 9.499e-06 3.3 9.5e-06 0 9.999e-06 0 1e-05 3.3 1.0499e-05 3.3 1.05e-05 0 1.4499e-05 0 1.45e-05 3.3 1.4999e-05 3.3 1.5e-05 0 1.6499e-05 0 1.65e-05 3.3 1.7499e-05 3.3 1.75e-05 0 1.7999e-05 0 1.8e-05 3.3 2.1999e-05 3.3 2.2e-05 0 2.2499e-05 0 2.25e-05 3.3 2.2999e-05 3.3 2.3e-05 0 2.3499e-05 0 2.35e-05 3.3 2.3999e-05 3.3 2.4e-05 0 2.4499e-05 0 2.45e-05 3.3 2.4999e-05 3.3 2.5e-05 0 2.5499e-05 0 2.55e-05 3.3 2.5999e-05 3.3 2.6e-05 0 2.6499e-05 0 2.65e-05 3.3 3.0499e-05 3.3 3.05e-05 0 3.0999e-05 0 3.1e-05 3.3 3.2499e-05 3.3 3.25e-05 0 3.3499e-05 0 3.35e-05 3.3 3.3999e-05 3.3 3.4e-05 0 3.7999e-05 0 3.8e-05 3.3 3.8499e-05 3.3 3.85e-05 0 3.8999e-05 0 3.9e-05 3.3 3.9499e-05 3.3 3.95e-05 0 3.9999e-05 0 4e-05 3.3 4.0499e-05 3.3 4.05e-05 0 4.0999e-05 0 4.1e-05 3.3 4.1499e-05 3.3 4.15e-05 0 4.1999e-05 0 4.2e-05 3.3 4.2499e-05 3.3 4.25e-05 0 4.6499e-05 0 4.65e-05 3.3 4.6999e-05 3.3 4.7e-05 0 4.8499e-05 0 4.85e-05 3.3 4.9499e-05 3.3 4.95e-05 0 4.9999e-05 0 5e-05 3.3 5.3999e-05 3.3 5.4e-05 0 5.4499e-05 0 5.45e-05 3.3 5.4999e-05 3.3 5.5e-05 0 5.5499e-05 0 5.55e-05 3.3 5.5999e-05 3.3 5.6e-05 0 5.6499e-05 0 5.65e-05 3.3 5.6999e-05 3.3 5.7e-05 0 5.7499e-05 0 5.75e-05 3.3 5.7999e-05 3.3 5.8e-05 0 5.8499e-05 0 5.85e-05 3.3 6.2499e-05 3.3 6.25e-05 0 6.2999e-05 0 6.3e-05 3.3 6.4499e-05 3.3 6.45e-05 0 6.5499e-05 0 6.55e-05 3.3 6.5999e-05 3.3 6.6e-05 0 6.9999e-05 0 7e-05 3.3 7.0499e-05 3.3 7.05e-05 0 7.0999e-05 0 7.1e-05 3.3 7.1499e-05 3.3 7.15e-05 0 7.1999e-05 0 7.2e-05 3.3 7.2499e-05 3.3 7.25e-05 0 7.2999e-05 0 7.3e-05 3.3 7.3499e-05 3.3 7.35e-05 0 7.3999e-05 0 7.4e-05 3.3 7.4499e-05 3.3 7.45e-05 0 7.8499e-05 0 7.85e-05 3.3 7.8999e-05 3.3 7.9e-05 0 8.0499e-05 0 8.05e-05 3.3 8.1499e-05 3.3 8.15e-05 0 8.1999e-05 0 8.2e-05 3.3 8.5999e-05 3.3 8.6e-05 0 8.6499e-05 0 8.65e-05 3.3 8.6999e-05 3.3 8.7e-05 0 8.7499e-05 0 8.75e-05 3.3 8.7999e-05 3.3 8.8e-05 0 8.8499e-05 0 8.85e-05 3.3 8.8999e-05 3.3 8.9e-05 0 8.9499e-05 0 8.95e-05 3.3 8.9999e-05 3.3 9e-05 0 9.0499e-05 0 9.05e-05 3.3 9.4499e-05 3.3 9.45e-05 0 9.4999e-05 0 9.5e-05 3.3 9.6499e-05 3.3 9.65e-05 0 9.7499e-05 0 9.75e-05 3.3 9.7999e-05 3.3 9.8e-05 0 0.000101999 0 0.000102 3.3 0.000102499 3.3 0.0001025 0 0.000102999 0 0.000103 3.3 0.000103499 3.3 0.0001035 0 0.000103999 0 0.000104 3.3 0.000104499 3.3 0.0001045 0 0.000104999 0 0.000105 3.3 0.000105499 3.3 0.0001055 0 0.000105999 0 0.000106 3.3 0.000106499 3.3 0.0001065 0 0.000110499 0 0.0001105 3.3 0.000110999 3.3 0.000111 0 0.000112499 0 0.0001125 3.3 0.000113499 3.3 0.0001135 0 0.000113999 0 0.000114 3.3 0.000117999 3.3 0.000118 0 0.000118499 0 0.0001185 3.3 0.000118999 3.3 0.000119 0 0.000119499 0 0.0001195 3.3 0.000119999 3.3 0.00012 0 0.000120499 0 0.0001205 3.3 0.000120999 3.3 0.000121 0 0.000121499 0 0.0001215 3.3 0.000121999 3.3 0.000122 0 0.000122499 0 0.0001225 3.3 0.000126499 3.3 0.0001265 0 0.000126999 0 0.000127 3.3 0.000128 3.3)
V11 B_5_3[1] GND PWL(0 0 2.999e-06 0 3e-06 3.3 3.499e-06 3.3 3.5e-06 0 3.999e-06 0 4e-06 3.3 5.499e-06 3.3 5.5e-06 0 6.499e-06 0 6.5e-06 3.3 6.999e-06 3.3 7e-06 0 7.499e-06 0 7.5e-06 3.3 8.999e-06 3.3 9e-06 0 9.499e-06 0 9.5e-06 3.3 9.999e-06 3.3 1e-05 0 1.0999e-05 0 1.1e-05 3.3 1.2499e-05 3.3 1.25e-05 0 1.2999e-05 0 1.3e-05 3.3 1.3499e-05 3.3 1.35e-05 0 1.6499e-05 0 1.65e-05 3.3 1.8999e-05 3.3 1.9e-05 0 1.9499e-05 0 1.95e-05 3.3 1.9999e-05 3.3 2e-05 0 2.1499e-05 0 2.15e-05 3.3 2.2499e-05 3.3 2.25e-05 0 2.2999e-05 0 2.3e-05 3.3 2.3499e-05 3.3 2.35e-05 0 2.4999e-05 0 2.5e-05 3.3 2.5499e-05 3.3 2.55e-05 0 2.5999e-05 0 2.6e-05 3.3 2.6999e-05 3.3 2.7e-05 0 2.8499e-05 0 2.85e-05 3.3 2.8999e-05 3.3 2.9e-05 0 2.9499e-05 0 2.95e-05 3.3 3.2499e-05 3.3 3.25e-05 0 3.4999e-05 0 3.5e-05 3.3 3.5499e-05 3.3 3.55e-05 0 3.5999e-05 0 3.6e-05 3.3 3.7499e-05 3.3 3.75e-05 0 3.8499e-05 0 3.85e-05 3.3 3.8999e-05 3.3 3.9e-05 0 3.9499e-05 0 3.95e-05 3.3 4.0999e-05 3.3 4.1e-05 0 4.1499e-05 0 4.15e-05 3.3 4.1999e-05 3.3 4.2e-05 0 4.2999e-05 0 4.3e-05 3.3 4.4499e-05 3.3 4.45e-05 0 4.4999e-05 0 4.5e-05 3.3 4.5499e-05 3.3 4.55e-05 0 4.8499e-05 0 4.85e-05 3.3 5.0999e-05 3.3 5.1e-05 0 5.1499e-05 0 5.15e-05 3.3 5.1999e-05 3.3 5.2e-05 0 5.3499e-05 0 5.35e-05 3.3 5.4499e-05 3.3 5.45e-05 0 5.4999e-05 0 5.5e-05 3.3 5.5499e-05 3.3 5.55e-05 0 5.6999e-05 0 5.7e-05 3.3 5.7499e-05 3.3 5.75e-05 0 5.7999e-05 0 5.8e-05 3.3 5.8999e-05 3.3 5.9e-05 0 6.0499e-05 0 6.05e-05 3.3 6.0999e-05 3.3 6.1e-05 0 6.1499e-05 0 6.15e-05 3.3 6.4499e-05 3.3 6.45e-05 0 6.6999e-05 0 6.7e-05 3.3 6.7499e-05 3.3 6.75e-05 0 6.7999e-05 0 6.8e-05 3.3 6.9499e-05 3.3 6.95e-05 0 7.0499e-05 0 7.05e-05 3.3 7.0999e-05 3.3 7.1e-05 0 7.1499e-05 0 7.15e-05 3.3 7.2999e-05 3.3 7.3e-05 0 7.3499e-05 0 7.35e-05 3.3 7.3999e-05 3.3 7.4e-05 0 7.4999e-05 0 7.5e-05 3.3 7.6499e-05 3.3 7.65e-05 0 7.6999e-05 0 7.7e-05 3.3 7.7499e-05 3.3 7.75e-05 0 8.0499e-05 0 8.05e-05 3.3 8.2999e-05 3.3 8.3e-05 0 8.3499e-05 0 8.35e-05 3.3 8.3999e-05 3.3 8.4e-05 0 8.5499e-05 0 8.55e-05 3.3 8.6499e-05 3.3 8.65e-05 0 8.6999e-05 0 8.7e-05 3.3 8.7499e-05 3.3 8.75e-05 0 8.8999e-05 0 8.9e-05 3.3 8.9499e-05 3.3 8.95e-05 0 8.9999e-05 0 9e-05 3.3 9.0999e-05 3.3 9.1e-05 0 9.2499e-05 0 9.25e-05 3.3 9.2999e-05 3.3 9.3e-05 0 9.3499e-05 0 9.35e-05 3.3 9.6499e-05 3.3 9.65e-05 0 9.8999e-05 0 9.9e-05 3.3 9.9499e-05 3.3 9.95e-05 0 9.9999e-05 0 0.0001 3.3 0.000101499 3.3 0.0001015 0 0.000102499 0 0.0001025 3.3 0.000102999 3.3 0.000103 0 0.000103499 0 0.0001035 3.3 0.000104999 3.3 0.000105 0 0.000105499 0 0.0001055 3.3 0.000105999 3.3 0.000106 0 0.000106999 0 0.000107 3.3 0.000108499 3.3 0.0001085 0 0.000108999 0 0.000109 3.3 0.000109499 3.3 0.0001095 0 0.000112499 0 0.0001125 3.3 0.000114999 3.3 0.000115 0 0.000115499 0 0.0001155 3.3 0.000115999 3.3 0.000116 0 0.000117499 0 0.0001175 3.3 0.000118499 3.3 0.0001185 0 0.000118999 0 0.000119 3.3 0.000119499 3.3 0.0001195 0 0.000120999 0 0.000121 3.3 0.000121499 3.3 0.0001215 0 0.000121999 0 0.000122 3.3 0.000122999 3.3 0.000123 0 0.000124499 0 0.0001245 3.3 0.000124999 3.3 0.000125 0 0.000125499 0 0.0001255 3.3 0.000128 3.3)
V12 B_5_3[2] GND PWL(0 0 4.99e-07 0 5e-07 3.3 9.99e-07 3.3 1e-06 0 1.499e-06 0 1.5e-06 3.3 1.999e-06 3.3 2e-06 0 2.499e-06 0 2.5e-06 3.3 3.499e-06 3.3 3.5e-06 0 5.999e-06 0 6e-06 3.3 6.499e-06 3.3 6.5e-06 0 6.999e-06 0 7e-06 3.3 9.499e-06 3.3 9.5e-06 0 9.999e-06 0 1e-05 3.3 1.0499e-05 3.3 1.05e-05 0 1.2999e-05 0 1.3e-05 3.3 1.3999e-05 3.3 1.4e-05 0 1.4499e-05 0 1.45e-05 3.3 1.4999e-05 3.3 1.5e-05 0 1.5499e-05 0 1.55e-05 3.3 1.5999e-05 3.3 1.6e-05 0 1.6999e-05 0 1.7e-05 3.3 1.7499e-05 3.3 1.75e-05 0 1.7999e-05 0 1.8e-05 3.3 1.8499e-05 3.3 1.85e-05 0 1.9499e-05 0 1.95e-05 3.3 2.1999e-05 3.3 2.2e-05 0 2.2499e-05 0 2.25e-05 3.3 2.2999e-05 3.3 2.3e-05 0 2.5499e-05 0 2.55e-05 3.3 2.5999e-05 3.3 2.6e-05 0 2.6499e-05 0 2.65e-05 3.3 2.8999e-05 3.3 2.9e-05 0 2.9999e-05 0 3e-05 3.3 3.0499e-05 3.3 3.05e-05 0 3.0999e-05 0 3.1e-05 3.3 3.1499e-05 3.3 3.15e-05 0 3.1999e-05 0 3.2e-05 3.3 3.2999e-05 3.3 3.3e-05 0 3.3499e-05 0 3.35e-05 3.3 3.3999e-05 3.3 3.4e-05 0 3.4499e-05 0 3.45e-05 3.3 3.5499e-05 3.3 3.55e-05 0 3.7999e-05 0 3.8e-05 3.3 3.8499e-05 3.3 3.85e-05 0 3.8999e-05 0 3.9e-05 3.3 4.1499e-05 3.3 4.15e-05 0 4.1999e-05 0 4.2e-05 3.3 4.2499e-05 3.3 4.25e-05 0 4.4999e-05 0 4.5e-05 3.3 4.5999e-05 3.3 4.6e-05 0 4.6499e-05 0 4.65e-05 3.3 4.6999e-05 3.3 4.7e-05 0 4.7499e-05 0 4.75e-05 3.3 4.7999e-05 3.3 4.8e-05 0 4.8999e-05 0 4.9e-05 3.3 4.9499e-05 3.3 4.95e-05 0 4.9999e-05 0 5e-05 3.3 5.0499e-05 3.3 5.05e-05 0 5.1499e-05 0 5.15e-05 3.3 5.3999e-05 3.3 5.4e-05 0 5.4499e-05 0 5.45e-05 3.3 5.4999e-05 3.3 5.5e-05 0 5.7499e-05 0 5.75e-05 3.3 5.7999e-05 3.3 5.8e-05 0 5.8499e-05 0 5.85e-05 3.3 6.0999e-05 3.3 6.1e-05 0 6.1999e-05 0 6.2e-05 3.3 6.2499e-05 3.3 6.25e-05 0 6.2999e-05 0 6.3e-05 3.3 6.3499e-05 3.3 6.35e-05 0 6.3999e-05 0 6.4e-05 3.3 6.4999e-05 3.3 6.5e-05 0 6.5499e-05 0 6.55e-05 3.3 6.5999e-05 3.3 6.6e-05 0 6.6499e-05 0 6.65e-05 3.3 6.7499e-05 3.3 6.75e-05 0 6.9999e-05 0 7e-05 3.3 7.0499e-05 3.3 7.05e-05 0 7.0999e-05 0 7.1e-05 3.3 7.3499e-05 3.3 7.35e-05 0 7.3999e-05 0 7.4e-05 3.3 7.4499e-05 3.3 7.45e-05 0 7.6999e-05 0 7.7e-05 3.3 7.7999e-05 3.3 7.8e-05 0 7.8499e-05 0 7.85e-05 3.3 7.8999e-05 3.3 7.9e-05 0 7.9499e-05 0 7.95e-05 3.3 7.9999e-05 3.3 8e-05 0 8.0999e-05 0 8.1e-05 3.3 8.1499e-05 3.3 8.15e-05 0 8.1999e-05 0 8.2e-05 3.3 8.2499e-05 3.3 8.25e-05 0 8.3499e-05 0 8.35e-05 3.3 8.5999e-05 3.3 8.6e-05 0 8.6499e-05 0 8.65e-05 3.3 8.6999e-05 3.3 8.7e-05 0 8.9499e-05 0 8.95e-05 3.3 8.9999e-05 3.3 9e-05 0 9.0499e-05 0 9.05e-05 3.3 9.2999e-05 3.3 9.3e-05 0 9.3999e-05 0 9.4e-05 3.3 9.4499e-05 3.3 9.45e-05 0 9.4999e-05 0 9.5e-05 3.3 9.5499e-05 3.3 9.55e-05 0 9.5999e-05 0 9.6e-05 3.3 9.6999e-05 3.3 9.7e-05 0 9.7499e-05 0 9.75e-05 3.3 9.7999e-05 3.3 9.8e-05 0 9.8499e-05 0 9.85e-05 3.3 9.9499e-05 3.3 9.95e-05 0 0.000101999 0 0.000102 3.3 0.000102499 3.3 0.0001025 0 0.000102999 0 0.000103 3.3 0.000105499 3.3 0.0001055 0 0.000105999 0 0.000106 3.3 0.000106499 3.3 0.0001065 0 0.000108999 0 0.000109 3.3 0.000109999 3.3 0.00011 0 0.000110499 0 0.0001105 3.3 0.000110999 3.3 0.000111 0 0.000111499 0 0.0001115 3.3 0.000111999 3.3 0.000112 0 0.000112999 0 0.000113 3.3 0.000113499 3.3 0.0001135 0 0.000113999 0 0.000114 3.3 0.000114499 3.3 0.0001145 0 0.000115499 0 0.0001155 3.3 0.000117999 3.3 0.000118 0 0.000118499 0 0.0001185 3.3 0.000118999 3.3 0.000119 0 0.000121499 0 0.0001215 3.3 0.000121999 3.3 0.000122 0 0.000122499 0 0.0001225 3.3 0.000124999 3.3 0.000125 0 0.000125999 0 0.000126 3.3 0.000126499 3.3 0.0001265 0 0.000126999 0 0.000127 3.3 0.000127499 3.3 0.0001275 0 0.000128 0)
V13 B_5_3[3] GND PWL(0 0 4.99e-07 0 5e-07 3.3 1.499e-06 3.3 1.5e-06 0 2.499e-06 0 2.5e-06 3.3 2.999e-06 3.3 3e-06 0 3.999e-06 0 4e-06 3.3 4.499e-06 3.3 4.5e-06 0 4.999e-06 0 5e-06 3.3 5.499e-06 3.3 5.5e-06 0 6.499e-06 0 6.5e-06 3.3 9.999e-06 3.3 1e-05 0 1.0999e-05 0 1.1e-05 3.3 1.1499e-05 3.3 1.15e-05 0 1.1999e-05 0 1.2e-05 3.3 1.2499e-05 3.3 1.25e-05 0 1.3499e-05 0 1.35e-05 3.3 1.3999e-05 3.3 1.4e-05 0 1.4999e-05 0 1.5e-05 3.3 1.5999e-05 3.3 1.6e-05 0 1.7499e-05 0 1.75e-05 3.3 1.8499e-05 3.3 1.85e-05 0 1.8999e-05 0 1.9e-05 3.3 1.9999e-05 3.3 2e-05 0 2.0499e-05 0 2.05e-05 3.3 2.0999e-05 3.3 2.1e-05 0 2.1499e-05 0 2.15e-05 3.3 2.2499e-05 3.3 2.25e-05 0 2.5999e-05 0 2.6e-05 3.3 2.6999e-05 3.3 2.7e-05 0 2.7499e-05 0 2.75e-05 3.3 2.7999e-05 3.3 2.8e-05 0 2.8499e-05 0 2.85e-05 3.3 2.9499e-05 3.3 2.95e-05 0 2.9999e-05 0 3e-05 3.3 3.0999e-05 3.3 3.1e-05 0 3.1999e-05 0 3.2e-05 3.3 3.3499e-05 3.3 3.35e-05 0 3.4499e-05 0 3.45e-05 3.3 3.4999e-05 3.3 3.5e-05 0 3.5999e-05 0 3.6e-05 3.3 3.6499e-05 3.3 3.65e-05 0 3.6999e-05 0 3.7e-05 3.3 3.7499e-05 3.3 3.75e-05 0 3.8499e-05 0 3.85e-05 3.3 4.1999e-05 3.3 4.2e-05 0 4.2999e-05 0 4.3e-05 3.3 4.3499e-05 3.3 4.35e-05 0 4.3999e-05 0 4.4e-05 3.3 4.4499e-05 3.3 4.45e-05 0 4.5499e-05 0 4.55e-05 3.3 4.5999e-05 3.3 4.6e-05 0 4.6999e-05 0 4.7e-05 3.3 4.7999e-05 3.3 4.8e-05 0 4.9499e-05 0 4.95e-05 3.3 5.0499e-05 3.3 5.05e-05 0 5.0999e-05 0 5.1e-05 3.3 5.1999e-05 3.3 5.2e-05 0 5.2499e-05 0 5.25e-05 3.3 5.2999e-05 3.3 5.3e-05 0 5.3499e-05 0 5.35e-05 3.3 5.4499e-05 3.3 5.45e-05 0 5.7999e-05 0 5.8e-05 3.3 5.8999e-05 3.3 5.9e-05 0 5.9499e-05 0 5.95e-05 3.3 5.9999e-05 3.3 6e-05 0 6.0499e-05 0 6.05e-05 3.3 6.1499e-05 3.3 6.15e-05 0 6.1999e-05 0 6.2e-05 3.3 6.2999e-05 3.3 6.3e-05 0 6.3999e-05 0 6.4e-05 3.3 6.5499e-05 3.3 6.55e-05 0 6.6499e-05 0 6.65e-05 3.3 6.6999e-05 3.3 6.7e-05 0 6.7999e-05 0 6.8e-05 3.3 6.8499e-05 3.3 6.85e-05 0 6.8999e-05 0 6.9e-05 3.3 6.9499e-05 3.3 6.95e-05 0 7.0499e-05 0 7.05e-05 3.3 7.3999e-05 3.3 7.4e-05 0 7.4999e-05 0 7.5e-05 3.3 7.5499e-05 3.3 7.55e-05 0 7.5999e-05 0 7.6e-05 3.3 7.6499e-05 3.3 7.65e-05 0 7.7499e-05 0 7.75e-05 3.3 7.7999e-05 3.3 7.8e-05 0 7.8999e-05 0 7.9e-05 3.3 7.9999e-05 3.3 8e-05 0 8.1499e-05 0 8.15e-05 3.3 8.2499e-05 3.3 8.25e-05 0 8.2999e-05 0 8.3e-05 3.3 8.3999e-05 3.3 8.4e-05 0 8.4499e-05 0 8.45e-05 3.3 8.4999e-05 3.3 8.5e-05 0 8.5499e-05 0 8.55e-05 3.3 8.6499e-05 3.3 8.65e-05 0 8.9999e-05 0 9e-05 3.3 9.0999e-05 3.3 9.1e-05 0 9.1499e-05 0 9.15e-05 3.3 9.1999e-05 3.3 9.2e-05 0 9.2499e-05 0 9.25e-05 3.3 9.3499e-05 3.3 9.35e-05 0 9.3999e-05 0 9.4e-05 3.3 9.4999e-05 3.3 9.5e-05 0 9.5999e-05 0 9.6e-05 3.3 9.7499e-05 3.3 9.75e-05 0 9.8499e-05 0 9.85e-05 3.3 9.8999e-05 3.3 9.9e-05 0 9.9999e-05 0 0.0001 3.3 0.000100499 3.3 0.0001005 0 0.000100999 0 0.000101 3.3 0.000101499 3.3 0.0001015 0 0.000102499 0 0.0001025 3.3 0.000105999 3.3 0.000106 0 0.000106999 0 0.000107 3.3 0.000107499 3.3 0.0001075 0 0.000107999 0 0.000108 3.3 0.000108499 3.3 0.0001085 0 0.000109499 0 0.0001095 3.3 0.000109999 3.3 0.00011 0 0.000110999 0 0.000111 3.3 0.000111999 3.3 0.000112 0 0.000113499 0 0.0001135 3.3 0.000114499 3.3 0.0001145 0 0.000114999 0 0.000115 3.3 0.000115999 3.3 0.000116 0 0.000116499 0 0.0001165 3.3 0.000116999 3.3 0.000117 0 0.000117499 0 0.0001175 3.3 0.000118499 3.3 0.0001185 0 0.000121999 0 0.000122 3.3 0.000122999 3.3 0.000123 0 0.000123499 0 0.0001235 3.3 0.000123999 3.3 0.000124 0 0.000124499 0 0.0001245 3.3 0.000125499 3.3 0.0001255 0 0.000125999 0 0.000126 3.3 0.000126999 3.3 0.000127 0 0.000128 0)
V14 B_5_3[4] GND PWL(0 0 9.99e-07 0 1e-06 3.3 1.499e-06 3.3 1.5e-06 0 1.999e-06 0 2e-06 3.3 2.999e-06 3.3 3e-06 0 3.499e-06 0 3.5e-06 3.3 4.499e-06 3.3 4.5e-06 0 5.499e-06 0 5.5e-06 3.3 1.0999e-05 3.3 1.1e-05 0 1.1999e-05 0 1.2e-05 3.3 1.2999e-05 3.3 1.3e-05 0 1.3499e-05 0 1.35e-05 3.3 1.4499e-05 3.3 1.45e-05 0 1.4999e-05 0 1.5e-05 3.3 1.5499e-05 3.3 1.55e-05 0 1.6499e-05 0 1.65e-05 3.3 1.6999e-05 3.3 1.7e-05 0 1.7499e-05 0 1.75e-05 3.3 1.7999e-05 3.3 1.8e-05 0 1.8999e-05 0 1.9e-05 3.3 1.9499e-05 3.3 1.95e-05 0 2.0499e-05 0 2.05e-05 3.3 2.1499e-05 3.3 2.15e-05 0 2.6999e-05 0 2.7e-05 3.3 2.7999e-05 3.3 2.8e-05 0 2.8999e-05 0 2.9e-05 3.3 2.9499e-05 3.3 2.95e-05 0 3.0499e-05 0 3.05e-05 3.3 3.0999e-05 3.3 3.1e-05 0 3.1499e-05 0 3.15e-05 3.3 3.2499e-05 3.3 3.25e-05 0 3.2999e-05 0 3.3e-05 3.3 3.3499e-05 3.3 3.35e-05 0 3.3999e-05 0 3.4e-05 3.3 3.4999e-05 3.3 3.5e-05 0 3.5499e-05 0 3.55e-05 3.3 3.6499e-05 3.3 3.65e-05 0 3.7499e-05 0 3.75e-05 3.3 4.2999e-05 3.3 4.3e-05 0 4.3999e-05 0 4.4e-05 3.3 4.4999e-05 3.3 4.5e-05 0 4.5499e-05 0 4.55e-05 3.3 4.6499e-05 3.3 4.65e-05 0 4.6999e-05 0 4.7e-05 3.3 4.7499e-05 3.3 4.75e-05 0 4.8499e-05 0 4.85e-05 3.3 4.8999e-05 3.3 4.9e-05 0 4.9499e-05 0 4.95e-05 3.3 4.9999e-05 3.3 5e-05 0 5.0999e-05 0 5.1e-05 3.3 5.1499e-05 3.3 5.15e-05 0 5.2499e-05 0 5.25e-05 3.3 5.3499e-05 3.3 5.35e-05 0 5.8999e-05 0 5.9e-05 3.3 5.9999e-05 3.3 6e-05 0 6.0999e-05 0 6.1e-05 3.3 6.1499e-05 3.3 6.15e-05 0 6.2499e-05 0 6.25e-05 3.3 6.2999e-05 3.3 6.3e-05 0 6.3499e-05 0 6.35e-05 3.3 6.4499e-05 3.3 6.45e-05 0 6.4999e-05 0 6.5e-05 3.3 6.5499e-05 3.3 6.55e-05 0 6.5999e-05 0 6.6e-05 3.3 6.6999e-05 3.3 6.7e-05 0 6.7499e-05 0 6.75e-05 3.3 6.8499e-05 3.3 6.85e-05 0 6.9499e-05 0 6.95e-05 3.3 7.4999e-05 3.3 7.5e-05 0 7.5999e-05 0 7.6e-05 3.3 7.6999e-05 3.3 7.7e-05 0 7.7499e-05 0 7.75e-05 3.3 7.8499e-05 3.3 7.85e-05 0 7.8999e-05 0 7.9e-05 3.3 7.9499e-05 3.3 7.95e-05 0 8.0499e-05 0 8.05e-05 3.3 8.0999e-05 3.3 8.1e-05 0 8.1499e-05 0 8.15e-05 3.3 8.1999e-05 3.3 8.2e-05 0 8.2999e-05 0 8.3e-05 3.3 8.3499e-05 3.3 8.35e-05 0 8.4499e-05 0 8.45e-05 3.3 8.5499e-05 3.3 8.55e-05 0 9.0999e-05 0 9.1e-05 3.3 9.1999e-05 3.3 9.2e-05 0 9.2999e-05 0 9.3e-05 3.3 9.3499e-05 3.3 9.35e-05 0 9.4499e-05 0 9.45e-05 3.3 9.4999e-05 3.3 9.5e-05 0 9.5499e-05 0 9.55e-05 3.3 9.6499e-05 3.3 9.65e-05 0 9.6999e-05 0 9.7e-05 3.3 9.7499e-05 3.3 9.75e-05 0 9.7999e-05 0 9.8e-05 3.3 9.8999e-05 3.3 9.9e-05 0 9.9499e-05 0 9.95e-05 3.3 0.000100499 3.3 0.0001005 0 0.000101499 0 0.0001015 3.3 0.000106999 3.3 0.000107 0 0.000107999 0 0.000108 3.3 0.000108999 3.3 0.000109 0 0.000109499 0 0.0001095 3.3 0.000110499 3.3 0.0001105 0 0.000110999 0 0.000111 3.3 0.000111499 3.3 0.0001115 0 0.000112499 0 0.0001125 3.3 0.000112999 3.3 0.000113 0 0.000113499 0 0.0001135 3.3 0.000113999 3.3 0.000114 0 0.000114999 0 0.000115 3.3 0.000115499 3.3 0.0001155 0 0.000116499 0 0.0001165 3.3 0.000117499 3.3 0.0001175 0 0.000122999 0 0.000123 3.3 0.000123999 3.3 0.000124 0 0.000124999 0 0.000125 3.3 0.000125499 3.3 0.0001255 0 0.000126499 0 0.0001265 3.3 0.000126999 3.3 0.000127 0 0.000127499 0 0.0001275 3.3 0.000128 3.3)
V15 T_5_3[0] GND PWL(0 3.3 2.0499e-05 3.3 2.05e-05 0 2.7999e-05 0 2.8e-05 3.3 5.2499e-05 3.3 5.25e-05 0 5.9999e-05 0 6e-05 3.3 8.4499e-05 3.3 8.45e-05 0 9.1999e-05 0 9.2e-05 3.3 0.000116499 3.3 0.0001165 0 0.000123999 0 0.000124 3.3 0.000128 3.3)
V16 T_5_3[1] GND PWL(0 3.3 1.8999e-05 3.3 1.9e-05 0 2.9499e-05 0 2.95e-05 3.3 5.0999e-05 3.3 5.1e-05 0 6.1499e-05 0 6.15e-05 3.3 8.2999e-05 3.3 8.3e-05 0 9.3499e-05 0 9.35e-05 3.3 0.000114999 3.3 0.000115 0 0.000125499 0 0.0001255 3.3 0.000128 3.3)
V17 T_5_3[2] GND PWL(0 3.3 1.7499e-05 3.3 1.75e-05 0 3.0999e-05 0 3.1e-05 3.3 4.9499e-05 3.3 4.95e-05 0 6.2999e-05 0 6.3e-05 3.3 8.1499e-05 3.3 8.15e-05 0 9.4999e-05 0 9.5e-05 3.3 0.000113499 3.3 0.0001135 0 0.000126999 0 0.000127 3.3 0.000128 3.3)
V18 T_5_3[3] GND PWL(0 3.3 1.6499e-05 3.3 1.65e-05 0 3.2499e-05 0 3.25e-05 3.3 4.8499e-05 3.3 4.85e-05 0 6.4499e-05 0 6.45e-05 3.3 8.0499e-05 3.3 8.05e-05 0 9.6499e-05 0 9.65e-05 3.3 0.000112499 3.3 0.0001125 0 0.000128 0)
V19 T_5_3[4] GND PWL(0 0 1.499e-06 0 1.5e-06 3.3 1.4999e-05 3.3 1.5e-05 0 3.3499e-05 0 3.35e-05 3.3 4.6999e-05 3.3 4.7e-05 0 6.5499e-05 0 6.55e-05 3.3 7.8999e-05 3.3 7.9e-05 0 9.7499e-05 0 9.75e-05 3.3 0.000110999 3.3 0.000111 0 0.000128 0)
V20 T_5_3[5] GND PWL(0 0 2.999e-06 0 3e-06 3.3 1.3499e-05 3.3 1.35e-05 0 3.4999e-05 0 3.5e-05 3.3 4.5499e-05 3.3 4.55e-05 0 6.6999e-05 0 6.7e-05 3.3 7.7499e-05 3.3 7.75e-05 0 9.8999e-05 0 9.9e-05 3.3 0.000109499 3.3 0.0001095 0 0.000128 0)
V21 T_5_3[6] GND PWL(0 0 4.499e-06 0 4.5e-06 3.3 1.1999e-05 3.3 1.2e-05 0 3.6499e-05 0 3.65e-05 3.3 4.3999e-05 3.3 4.4e-05 0 6.8499e-05 0 6.85e-05 3.3 7.5999e-05 3.3 7.6e-05 0 0.000100499 0 0.0001005 3.3 0.000107999 3.3 0.000108 0 0.000128 0)
