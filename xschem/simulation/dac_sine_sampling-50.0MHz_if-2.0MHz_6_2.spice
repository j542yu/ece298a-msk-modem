* DAC bits: 8
* Number of code intervals: 800
* Dwell: 2e-08 s
* Edge duration: 1e-09 s
* Simulation duration: 1.6e-05 s

V1 B_6_2[0] GND PWL(0 3.3 3.9e-08 3.3 4e-08 0 5.9e-08 0 6e-08 3.3 7.9e-08 3.3 8e-08 0 1.59e-07 0 1.6e-07 3.3 1.79e-07 3.3 1.8e-07 0 1.99e-07 0 2e-07 3.3 2.79e-07 3.3 2.8e-07 0 3.59e-07 0 3.6e-07 3.3 3.99e-07 3.3 4e-07 0 4.59e-07 0 4.6e-07 3.3 4.79e-07 3.3 4.8e-07 0 5.39e-07 0 5.4e-07 3.3 5.79e-07 3.3 5.8e-07 0 6.59e-07 0 6.6e-07 3.3 6.79e-07 3.3 6.8e-07 0 6.99e-07 0 7e-07 3.3 7.59e-07 3.3 7.6e-07 0 7.99e-07 0 8e-07 3.3 8.39e-07 3.3 8.4e-07 0 8.79e-07 0 8.8e-07 3.3 9.39e-07 3.3 9.4e-07 0 9.59e-07 0 9.6e-07 3.3 9.79e-07 3.3 9.8e-07 0 9.99e-07 0 1e-06 3.3 1.019e-06 3.3 1.02e-06 0 1.079e-06 0 1.08e-06 3.3 1.099e-06 3.3 1.1e-06 0 1.119e-06 0 1.12e-06 3.3 1.139e-06 3.3 1.14e-06 0 1.159e-06 0 1.16e-06 3.3 1.179e-06 3.3 1.18e-06 0 1.219e-06 0 1.22e-06 3.3 1.259e-06 3.3 1.26e-06 0 1.279e-06 0 1.28e-06 3.3 1.299e-06 3.3 1.3e-06 0 1.319e-06 0 1.32e-06 3.3 1.339e-06 3.3 1.34e-06 0 1.399e-06 0 1.4e-06 3.3 1.439e-06 3.3 1.44e-06 0 1.459e-06 0 1.46e-06 3.3 1.499e-06 3.3 1.5e-06 0 1.519e-06 0 1.52e-06 3.3 1.579e-06 3.3 1.58e-06 0 1.599e-06 0 1.6e-06 3.3 1.619e-06 3.3 1.62e-06 0 1.639e-06 0 1.64e-06 3.3 1.659e-06 3.3 1.66e-06 0 1.679e-06 0 1.68e-06 3.3 1.739e-06 3.3 1.74e-06 0 1.799e-06 0 1.8e-06 3.3 1.839e-06 3.3 1.84e-06 0 1.959e-06 0 1.96e-06 3.3 1.999e-06 3.3 2e-06 0 2.039e-06 0 2.04e-06 3.3 2.099e-06 3.3 2.1e-06 0 2.159e-06 0 2.16e-06 3.3 2.219e-06 3.3 2.22e-06 0 2.239e-06 0 2.24e-06 3.3 2.259e-06 3.3 2.26e-06 0 2.319e-06 0 2.32e-06 3.3 2.379e-06 3.3 2.38e-06 0 2.419e-06 0 2.42e-06 3.3 2.439e-06 3.3 2.44e-06 0 2.459e-06 0 2.46e-06 3.3 2.479e-06 3.3 2.48e-06 0 2.539e-06 0 2.54e-06 3.3 2.559e-06 3.3 2.56e-06 0 2.619e-06 0 2.62e-06 3.3 2.719e-06 3.3 2.72e-06 0 2.779e-06 0 2.78e-06 3.3 2.799e-06 3.3 2.8e-06 0 2.819e-06 0 2.82e-06 3.3 2.859e-06 3.3 2.86e-06 0 2.919e-06 0 2.92e-06 3.3 2.939e-06 3.3 2.94e-06 0 2.959e-06 0 2.96e-06 3.3 2.979e-06 3.3 2.98e-06 0 3.019e-06 0 3.02e-06 3.3 3.099e-06 3.3 3.1e-06 0 3.119e-06 0 3.12e-06 3.3 3.199e-06 3.3 3.2e-06 0 3.239e-06 0 3.24e-06 3.3 3.279e-06 3.3 3.28e-06 0 3.399e-06 0 3.4e-06 3.3 3.419e-06 3.3 3.42e-06 0 3.479e-06 0 3.48e-06 3.3 3.579e-06 3.3 3.58e-06 0 3.599e-06 0 3.6e-06 3.3 3.619e-06 3.3 3.62e-06 0 3.699e-06 0 3.7e-06 3.3 3.799e-06 3.3 3.8e-06 0 3.819e-06 0 3.82e-06 3.3 3.859e-06 3.3 3.86e-06 0 3.899e-06 0 3.9e-06 3.3 3.919e-06 3.3 3.92e-06 0 3.939e-06 0 3.94e-06 3.3 3.959e-06 3.3 3.96e-06 0 3.999e-06 0 4e-06 3.3 4.059e-06 3.3 4.06e-06 0 4.139e-06 0 4.14e-06 3.3 4.259e-06 3.3 4.26e-06 0 4.279e-06 0 4.28e-06 3.3 4.299e-06 3.3 4.3e-06 0 4.319e-06 0 4.32e-06 3.3 4.339e-06 3.3 4.34e-06 0 4.359e-06 0 4.36e-06 3.3 4.379e-06 3.3 4.38e-06 0 4.459e-06 0 4.46e-06 3.3 4.519e-06 3.3 4.52e-06 0 4.539e-06 0 4.54e-06 3.3 4.619e-06 3.3 4.62e-06 0 4.639e-06 0 4.64e-06 3.3 4.659e-06 3.3 4.66e-06 0 4.679e-06 0 4.68e-06 3.3 4.779e-06 3.3 4.78e-06 0 4.819e-06 0 4.82e-06 3.3 4.859e-06 3.3 4.86e-06 0 4.879e-06 0 4.88e-06 3.3 4.919e-06 3.3 4.92e-06 0 5.059e-06 0 5.06e-06 3.3 5.079e-06 3.3 5.08e-06 0 5.139e-06 0 5.14e-06 3.3 5.199e-06 3.3 5.2e-06 0 5.219e-06 0 5.22e-06 3.3 5.239e-06 3.3 5.24e-06 0 5.259e-06 0 5.26e-06 3.3 5.299e-06 3.3 5.3e-06 0 5.339e-06 0 5.34e-06 3.3 5.359e-06 3.3 5.36e-06 0 5.379e-06 0 5.38e-06 3.3 5.419e-06 3.3 5.42e-06 0 5.459e-06 0 5.46e-06 3.3 5.499e-06 3.3 5.5e-06 0 5.519e-06 0 5.52e-06 3.3 5.559e-06 3.3 5.56e-06 0 5.599e-06 0 5.6e-06 3.3 5.619e-06 3.3 5.62e-06 0 5.659e-06 0 5.66e-06 3.3 5.719e-06 3.3 5.72e-06 0 5.739e-06 0 5.74e-06 3.3 5.779e-06 3.3 5.78e-06 0 5.819e-06 0 5.82e-06 3.3 5.839e-06 3.3 5.84e-06 0 5.879e-06 0 5.88e-06 3.3 5.899e-06 3.3 5.9e-06 0 6.139e-06 0 6.14e-06 3.3 6.179e-06 3.3 6.18e-06 0 6.199e-06 0 6.2e-06 3.3 6.219e-06 3.3 6.22e-06 0 6.239e-06 0 6.24e-06 3.3 6.299e-06 3.3 6.3e-06 0 6.319e-06 0 6.32e-06 3.3 6.339e-06 3.3 6.34e-06 0 6.359e-06 0 6.36e-06 3.3 6.419e-06 3.3 6.42e-06 0 6.559e-06 0 6.56e-06 3.3 6.579e-06 3.3 6.58e-06 0 6.599e-06 0 6.6e-06 3.3 6.619e-06 3.3 6.62e-06 0 6.639e-06 0 6.64e-06 3.3 6.659e-06 3.3 6.66e-06 0 6.699e-06 0 6.7e-06 3.3 6.799e-06 3.3 6.8e-06 0 6.819e-06 0 6.82e-06 3.3 6.839e-06 3.3 6.84e-06 0 6.939e-06 0 6.94e-06 3.3 7.059e-06 3.3 7.06e-06 0 7.119e-06 0 7.12e-06 3.3 7.139e-06 3.3 7.14e-06 0 7.159e-06 0 7.16e-06 3.3 7.179e-06 3.3 7.18e-06 0 7.319e-06 0 7.32e-06 3.3 7.339e-06 3.3 7.34e-06 0 7.379e-06 0 7.38e-06 3.3 7.419e-06 3.3 7.42e-06 0 7.459e-06 0 7.46e-06 3.3 7.499e-06 3.3 7.5e-06 0 7.519e-06 0 7.52e-06 3.3 7.539e-06 3.3 7.54e-06 0 7.579e-06 0 7.58e-06 3.3 7.679e-06 3.3 7.68e-06 0 7.699e-06 0 7.7e-06 3.3 7.719e-06 3.3 7.72e-06 0 7.739e-06 0 7.74e-06 3.3 7.839e-06 3.3 7.84e-06 0 7.879e-06 0 7.88e-06 3.3 7.919e-06 3.3 7.92e-06 0 7.959e-06 0 7.96e-06 3.3 7.979e-06 3.3 7.98e-06 0 7.999e-06 0 8e-06 3.3 8.039e-06 3.3 8.04e-06 0 8.059e-06 0 8.06e-06 3.3 8.079e-06 3.3 8.08e-06 0 8.159e-06 0 8.16e-06 3.3 8.179e-06 3.3 8.18e-06 0 8.199e-06 0 8.2e-06 3.3 8.279e-06 3.3 8.28e-06 0 8.359e-06 0 8.36e-06 3.3 8.399e-06 3.3 8.4e-06 0 8.459e-06 0 8.46e-06 3.3 8.479e-06 3.3 8.48e-06 0 8.539e-06 0 8.54e-06 3.3 8.579e-06 3.3 8.58e-06 0 8.659e-06 0 8.66e-06 3.3 8.679e-06 3.3 8.68e-06 0 8.699e-06 0 8.7e-06 3.3 8.759e-06 3.3 8.76e-06 0 8.799e-06 0 8.8e-06 3.3 8.839e-06 3.3 8.84e-06 0 8.879e-06 0 8.88e-06 3.3 8.939e-06 3.3 8.94e-06 0 8.959e-06 0 8.96e-06 3.3 8.979e-06 3.3 8.98e-06 0 8.999e-06 0 9e-06 3.3 9.019e-06 3.3 9.02e-06 0 9.079e-06 0 9.08e-06 3.3 9.099e-06 3.3 9.1e-06 0 9.119e-06 0 9.12e-06 3.3 9.139e-06 3.3 9.14e-06 0 9.159e-06 0 9.16e-06 3.3 9.179e-06 3.3 9.18e-06 0 9.219e-06 0 9.22e-06 3.3 9.259e-06 3.3 9.26e-06 0 9.279e-06 0 9.28e-06 3.3 9.299e-06 3.3 9.3e-06 0 9.319e-06 0 9.32e-06 3.3 9.339e-06 3.3 9.34e-06 0 9.399e-06 0 9.4e-06 3.3 9.439e-06 3.3 9.44e-06 0 9.459e-06 0 9.46e-06 3.3 9.499e-06 3.3 9.5e-06 0 9.519e-06 0 9.52e-06 3.3 9.579e-06 3.3 9.58e-06 0 9.599e-06 0 9.6e-06 3.3 9.619e-06 3.3 9.62e-06 0 9.639e-06 0 9.64e-06 3.3 9.659e-06 3.3 9.66e-06 0 9.679e-06 0 9.68e-06 3.3 9.739e-06 3.3 9.74e-06 0 9.799e-06 0 9.8e-06 3.3 9.839e-06 3.3 9.84e-06 0 9.959e-06 0 9.96e-06 3.3 9.999e-06 3.3 1e-05 0 1.0039e-05 0 1.004e-05 3.3 1.0099e-05 3.3 1.01e-05 0 1.0159e-05 0 1.016e-05 3.3 1.0219e-05 3.3 1.022e-05 0 1.0239e-05 0 1.024e-05 3.3 1.0259e-05 3.3 1.026e-05 0 1.0319e-05 0 1.032e-05 3.3 1.0379e-05 3.3 1.038e-05 0 1.0419e-05 0 1.042e-05 3.3 1.0439e-05 3.3 1.044e-05 0 1.0459e-05 0 1.046e-05 3.3 1.0479e-05 3.3 1.048e-05 0 1.0539e-05 0 1.054e-05 3.3 1.0559e-05 3.3 1.056e-05 0 1.0619e-05 0 1.062e-05 3.3 1.0719e-05 3.3 1.072e-05 0 1.0779e-05 0 1.078e-05 3.3 1.0799e-05 3.3 1.08e-05 0 1.0819e-05 0 1.082e-05 3.3 1.0859e-05 3.3 1.086e-05 0 1.0919e-05 0 1.092e-05 3.3 1.0939e-05 3.3 1.094e-05 0 1.0959e-05 0 1.096e-05 3.3 1.0979e-05 3.3 1.098e-05 0 1.1019e-05 0 1.102e-05 3.3 1.1099e-05 3.3 1.11e-05 0 1.1119e-05 0 1.112e-05 3.3 1.1199e-05 3.3 1.12e-05 0 1.1239e-05 0 1.124e-05 3.3 1.1279e-05 3.3 1.128e-05 0 1.1399e-05 0 1.14e-05 3.3 1.1419e-05 3.3 1.142e-05 0 1.1479e-05 0 1.148e-05 3.3 1.1579e-05 3.3 1.158e-05 0 1.1599e-05 0 1.16e-05 3.3 1.1619e-05 3.3 1.162e-05 0 1.1699e-05 0 1.17e-05 3.3 1.1799e-05 3.3 1.18e-05 0 1.1819e-05 0 1.182e-05 3.3 1.1859e-05 3.3 1.186e-05 0 1.1899e-05 0 1.19e-05 3.3 1.1919e-05 3.3 1.192e-05 0 1.1939e-05 0 1.194e-05 3.3 1.1959e-05 3.3 1.196e-05 0 1.1999e-05 0 1.2e-05 3.3 1.2059e-05 3.3 1.206e-05 0 1.2139e-05 0 1.214e-05 3.3 1.2259e-05 3.3 1.226e-05 0 1.2279e-05 0 1.228e-05 3.3 1.2299e-05 3.3 1.23e-05 0 1.2319e-05 0 1.232e-05 3.3 1.2339e-05 3.3 1.234e-05 0 1.2359e-05 0 1.236e-05 3.3 1.2379e-05 3.3 1.238e-05 0 1.2459e-05 0 1.246e-05 3.3 1.2519e-05 3.3 1.252e-05 0 1.2539e-05 0 1.254e-05 3.3 1.2619e-05 3.3 1.262e-05 0 1.2639e-05 0 1.264e-05 3.3 1.2659e-05 3.3 1.266e-05 0 1.2679e-05 0 1.268e-05 3.3 1.2779e-05 3.3 1.278e-05 0 1.2819e-05 0 1.282e-05 3.3 1.2859e-05 3.3 1.286e-05 0 1.2879e-05 0 1.288e-05 3.3 1.2919e-05 3.3 1.292e-05 0 1.3059e-05 0 1.306e-05 3.3 1.3079e-05 3.3 1.308e-05 0 1.3139e-05 0 1.314e-05 3.3 1.3199e-05 3.3 1.32e-05 0 1.3219e-05 0 1.322e-05 3.3 1.3239e-05 3.3 1.324e-05 0 1.3259e-05 0 1.326e-05 3.3 1.3299e-05 3.3 1.33e-05 0 1.3339e-05 0 1.334e-05 3.3 1.3359e-05 3.3 1.336e-05 0 1.3379e-05 0 1.338e-05 3.3 1.3419e-05 3.3 1.342e-05 0 1.3459e-05 0 1.346e-05 3.3 1.3499e-05 3.3 1.35e-05 0 1.3519e-05 0 1.352e-05 3.3 1.3559e-05 3.3 1.356e-05 0 1.3599e-05 0 1.36e-05 3.3 1.3619e-05 3.3 1.362e-05 0 1.3659e-05 0 1.366e-05 3.3 1.3719e-05 3.3 1.372e-05 0 1.3739e-05 0 1.374e-05 3.3 1.3779e-05 3.3 1.378e-05 0 1.3819e-05 0 1.382e-05 3.3 1.3839e-05 3.3 1.384e-05 0 1.3879e-05 0 1.388e-05 3.3 1.3899e-05 3.3 1.39e-05 0 1.4139e-05 0 1.414e-05 3.3 1.4179e-05 3.3 1.418e-05 0 1.4199e-05 0 1.42e-05 3.3 1.4219e-05 3.3 1.422e-05 0 1.4239e-05 0 1.424e-05 3.3 1.4299e-05 3.3 1.43e-05 0 1.4319e-05 0 1.432e-05 3.3 1.4339e-05 3.3 1.434e-05 0 1.4359e-05 0 1.436e-05 3.3 1.4419e-05 3.3 1.442e-05 0 1.4559e-05 0 1.456e-05 3.3 1.4579e-05 3.3 1.458e-05 0 1.4599e-05 0 1.46e-05 3.3 1.4619e-05 3.3 1.462e-05 0 1.4639e-05 0 1.464e-05 3.3 1.4659e-05 3.3 1.466e-05 0 1.4699e-05 0 1.47e-05 3.3 1.4799e-05 3.3 1.48e-05 0 1.4819e-05 0 1.482e-05 3.3 1.4839e-05 3.3 1.484e-05 0 1.4939e-05 0 1.494e-05 3.3 1.5059e-05 3.3 1.506e-05 0 1.5119e-05 0 1.512e-05 3.3 1.5139e-05 3.3 1.514e-05 0 1.5159e-05 0 1.516e-05 3.3 1.5179e-05 3.3 1.518e-05 0 1.5319e-05 0 1.532e-05 3.3 1.5339e-05 3.3 1.534e-05 0 1.5379e-05 0 1.538e-05 3.3 1.5419e-05 3.3 1.542e-05 0 1.5459e-05 0 1.546e-05 3.3 1.5499e-05 3.3 1.55e-05 0 1.5519e-05 0 1.552e-05 3.3 1.5539e-05 3.3 1.554e-05 0 1.5579e-05 0 1.558e-05 3.3 1.5679e-05 3.3 1.568e-05 0 1.5699e-05 0 1.57e-05 3.3 1.5719e-05 3.3 1.572e-05 0 1.5739e-05 0 1.574e-05 3.3 1.5839e-05 3.3 1.584e-05 0 1.5879e-05 0 1.588e-05 3.3 1.5919e-05 3.3 1.592e-05 0 1.5959e-05 0 1.596e-05 3.3 1.5979e-05 3.3 1.598e-05 0 1.6e-05 0)
V2 B_6_2[1] GND PWL(0 3.3 5.9e-08 3.3 6e-08 0 9.9e-08 0 1e-07 3.3 1.19e-07 3.3 1.2e-07 0 1.39e-07 0 1.4e-07 3.3 1.79e-07 3.3 1.8e-07 0 3.19e-07 0 3.2e-07 3.3 3.39e-07 3.3 3.4e-07 0 3.79e-07 0 3.8e-07 3.3 4.19e-07 3.3 4.2e-07 0 4.39e-07 0 4.4e-07 3.3 4.59e-07 3.3 4.6e-07 0 5.59e-07 0 5.6e-07 3.3 5.79e-07 3.3 5.8e-07 0 5.99e-07 0 6e-07 3.3 6.19e-07 3.3 6.2e-07 0 6.79e-07 0 6.8e-07 3.3 7.19e-07 3.3 7.2e-07 0 7.39e-07 0 7.4e-07 3.3 7.59e-07 3.3 7.6e-07 0 7.79e-07 0 7.8e-07 3.3 7.99e-07 3.3 8e-07 0 8.19e-07 0 8.2e-07 3.3 8.39e-07 3.3 8.4e-07 0 8.59e-07 0 8.6e-07 3.3 8.99e-07 3.3 9e-07 0 9.39e-07 0 9.4e-07 3.3 9.99e-07 3.3 1e-06 0 1.039e-06 0 1.04e-06 3.3 1.059e-06 3.3 1.06e-06 0 1.099e-06 0 1.1e-06 3.3 1.159e-06 3.3 1.16e-06 0 1.219e-06 0 1.22e-06 3.3 1.239e-06 3.3 1.24e-06 0 1.319e-06 0 1.32e-06 3.3 1.439e-06 3.3 1.44e-06 0 1.499e-06 0 1.5e-06 3.3 1.519e-06 3.3 1.52e-06 0 1.539e-06 0 1.54e-06 3.3 1.579e-06 3.3 1.58e-06 0 1.599e-06 0 1.6e-06 3.3 1.619e-06 3.3 1.62e-06 0 1.659e-06 0 1.66e-06 3.3 1.699e-06 3.3 1.7e-06 0 1.739e-06 0 1.74e-06 3.3 1.759e-06 3.3 1.76e-06 0 1.779e-06 0 1.78e-06 3.3 1.819e-06 3.3 1.82e-06 0 1.859e-06 0 1.86e-06 3.3 1.919e-06 3.3 1.92e-06 0 1.939e-06 0 1.94e-06 3.3 1.979e-06 3.3 1.98e-06 0 1.999e-06 0 2e-06 3.3 2.119e-06 3.3 2.12e-06 0 2.139e-06 0 2.14e-06 3.3 2.199e-06 3.3 2.2e-06 0 2.359e-06 0 2.36e-06 3.3 2.379e-06 3.3 2.38e-06 0 2.399e-06 0 2.4e-06 3.3 2.479e-06 3.3 2.48e-06 0 2.499e-06 0 2.5e-06 3.3 2.539e-06 3.3 2.54e-06 0 2.599e-06 0 2.6e-06 3.3 2.619e-06 3.3 2.62e-06 0 2.639e-06 0 2.64e-06 3.3 2.659e-06 3.3 2.66e-06 0 2.679e-06 0 2.68e-06 3.3 2.699e-06 3.3 2.7e-06 0 2.719e-06 0 2.72e-06 3.3 2.759e-06 3.3 2.76e-06 0 2.779e-06 0 2.78e-06 3.3 2.819e-06 3.3 2.82e-06 0 2.899e-06 0 2.9e-06 3.3 2.919e-06 3.3 2.92e-06 0 2.959e-06 0 2.96e-06 3.3 2.999e-06 3.3 3e-06 0 3.019e-06 0 3.02e-06 3.3 3.039e-06 3.3 3.04e-06 0 3.059e-06 0 3.06e-06 3.3 3.079e-06 3.3 3.08e-06 0 3.099e-06 0 3.1e-06 3.3 3.139e-06 3.3 3.14e-06 0 3.179e-06 0 3.18e-06 3.3 3.199e-06 3.3 3.2e-06 0 3.279e-06 0 3.28e-06 3.3 3.299e-06 3.3 3.3e-06 0 3.319e-06 0 3.32e-06 3.3 3.339e-06 3.3 3.34e-06 0 3.359e-06 0 3.36e-06 3.3 3.379e-06 3.3 3.38e-06 0 3.399e-06 0 3.4e-06 3.3 3.419e-06 3.3 3.42e-06 0 3.459e-06 0 3.46e-06 3.3 3.479e-06 3.3 3.48e-06 0 3.519e-06 0 3.52e-06 3.3 3.539e-06 3.3 3.54e-06 0 3.559e-06 0 3.56e-06 3.3 3.579e-06 3.3 3.58e-06 0 3.619e-06 0 3.62e-06 3.3 3.699e-06 3.3 3.7e-06 0 3.739e-06 0 3.74e-06 3.3 3.799e-06 3.3 3.8e-06 0 3.879e-06 0 3.88e-06 3.3 3.899e-06 3.3 3.9e-06 0 3.939e-06 0 3.94e-06 3.3 3.979e-06 3.3 3.98e-06 0 3.999e-06 0 4e-06 3.3 4.059e-06 3.3 4.06e-06 0 4.179e-06 0 4.18e-06 3.3 4.199e-06 3.3 4.2e-06 0 4.219e-06 0 4.22e-06 3.3 4.239e-06 3.3 4.24e-06 0 4.279e-06 0 4.28e-06 3.3 4.319e-06 3.3 4.32e-06 0 4.359e-06 0 4.36e-06 3.3 4.419e-06 3.3 4.42e-06 0 4.479e-06 0 4.48e-06 3.3 4.499e-06 3.3 4.5e-06 0 4.519e-06 0 4.52e-06 3.3 4.639e-06 3.3 4.64e-06 0 4.659e-06 0 4.66e-06 3.3 4.699e-06 3.3 4.7e-06 0 4.739e-06 0 4.74e-06 3.3 4.759e-06 3.3 4.76e-06 0 4.779e-06 0 4.78e-06 3.3 4.799e-06 3.3 4.8e-06 0 4.859e-06 0 4.86e-06 3.3 4.899e-06 3.3 4.9e-06 0 4.919e-06 0 4.92e-06 3.3 4.939e-06 3.3 4.94e-06 0 4.959e-06 0 4.96e-06 3.3 4.979e-06 3.3 4.98e-06 0 5.019e-06 0 5.02e-06 3.3 5.059e-06 3.3 5.06e-06 0 5.099e-06 0 5.1e-06 3.3 5.119e-06 3.3 5.12e-06 0 5.179e-06 0 5.18e-06 3.3 5.199e-06 3.3 5.2e-06 0 5.239e-06 0 5.24e-06 3.3 5.279e-06 3.3 5.28e-06 0 5.299e-06 0 5.3e-06 3.3 5.339e-06 3.3 5.34e-06 0 5.359e-06 0 5.36e-06 3.3 5.399e-06 3.3 5.4e-06 0 5.419e-06 0 5.42e-06 3.3 5.439e-06 3.3 5.44e-06 0 5.499e-06 0 5.5e-06 3.3 5.519e-06 3.3 5.52e-06 0 5.579e-06 0 5.58e-06 3.3 5.599e-06 3.3 5.6e-06 0 5.619e-06 0 5.62e-06 3.3 5.659e-06 3.3 5.66e-06 0 5.679e-06 0 5.68e-06 3.3 5.719e-06 3.3 5.72e-06 0 5.739e-06 0 5.74e-06 3.3 5.759e-06 3.3 5.76e-06 0 5.779e-06 0 5.78e-06 3.3 5.799e-06 3.3 5.8e-06 0 5.859e-06 0 5.86e-06 3.3 5.879e-06 3.3 5.88e-06 0 5.959e-06 0 5.96e-06 3.3 6.019e-06 3.3 6.02e-06 0 6.039e-06 0 6.04e-06 3.3 6.059e-06 3.3 6.06e-06 0 6.099e-06 0 6.1e-06 3.3 6.119e-06 3.3 6.12e-06 0 6.159e-06 0 6.16e-06 3.3 6.179e-06 3.3 6.18e-06 0 6.219e-06 0 6.22e-06 3.3 6.299e-06 3.3 6.3e-06 0 6.339e-06 0 6.34e-06 3.3 6.359e-06 3.3 6.36e-06 0 6.379e-06 0 6.38e-06 3.3 6.439e-06 3.3 6.44e-06 0 6.459e-06 0 6.46e-06 3.3 6.479e-06 3.3 6.48e-06 0 6.499e-06 0 6.5e-06 3.3 6.519e-06 3.3 6.52e-06 0 6.539e-06 0 6.54e-06 3.3 6.699e-06 3.3 6.7e-06 0 6.739e-06 0 6.74e-06 3.3 6.759e-06 3.3 6.76e-06 0 6.779e-06 0 6.78e-06 3.3 6.819e-06 3.3 6.82e-06 0 6.919e-06 0 6.92e-06 3.3 6.979e-06 3.3 6.98e-06 0 7.019e-06 0 7.02e-06 3.3 7.059e-06 3.3 7.06e-06 0 7.119e-06 0 7.12e-06 3.3 7.159e-06 3.3 7.16e-06 0 7.199e-06 0 7.2e-06 3.3 7.259e-06 3.3 7.26e-06 0 7.279e-06 0 7.28e-06 3.3 7.299e-06 3.3 7.3e-06 0 7.319e-06 0 7.32e-06 3.3 7.339e-06 3.3 7.34e-06 0 7.379e-06 0 7.38e-06 3.3 7.399e-06 3.3 7.4e-06 0 7.459e-06 0 7.46e-06 3.3 7.479e-06 3.3 7.48e-06 0 7.519e-06 0 7.52e-06 3.3 7.559e-06 3.3 7.56e-06 0 7.579e-06 0 7.58e-06 3.3 7.599e-06 3.3 7.6e-06 0 7.679e-06 0 7.68e-06 3.3 7.699e-06 3.3 7.7e-06 0 7.739e-06 0 7.74e-06 3.3 7.839e-06 3.3 7.84e-06 0 7.959e-06 0 7.96e-06 3.3 8.059e-06 3.3 8.06e-06 0 8.099e-06 0 8.1e-06 3.3 8.119e-06 3.3 8.12e-06 0 8.139e-06 0 8.14e-06 3.3 8.179e-06 3.3 8.18e-06 0 8.319e-06 0 8.32e-06 3.3 8.339e-06 3.3 8.34e-06 0 8.379e-06 0 8.38e-06 3.3 8.419e-06 3.3 8.42e-06 0 8.439e-06 0 8.44e-06 3.3 8.459e-06 3.3 8.46e-06 0 8.559e-06 0 8.56e-06 3.3 8.579e-06 3.3 8.58e-06 0 8.599e-06 0 8.6e-06 3.3 8.619e-06 3.3 8.62e-06 0 8.679e-06 0 8.68e-06 3.3 8.719e-06 3.3 8.72e-06 0 8.739e-06 0 8.74e-06 3.3 8.759e-06 3.3 8.76e-06 0 8.779e-06 0 8.78e-06 3.3 8.799e-06 3.3 8.8e-06 0 8.819e-06 0 8.82e-06 3.3 8.839e-06 3.3 8.84e-06 0 8.859e-06 0 8.86e-06 3.3 8.899e-06 3.3 8.9e-06 0 8.939e-06 0 8.94e-06 3.3 8.999e-06 3.3 9e-06 0 9.039e-06 0 9.04e-06 3.3 9.059e-06 3.3 9.06e-06 0 9.099e-06 0 9.1e-06 3.3 9.159e-06 3.3 9.16e-06 0 9.219e-06 0 9.22e-06 3.3 9.239e-06 3.3 9.24e-06 0 9.319e-06 0 9.32e-06 3.3 9.439e-06 3.3 9.44e-06 0 9.499e-06 0 9.5e-06 3.3 9.519e-06 3.3 9.52e-06 0 9.539e-06 0 9.54e-06 3.3 9.579e-06 3.3 9.58e-06 0 9.599e-06 0 9.6e-06 3.3 9.619e-06 3.3 9.62e-06 0 9.659e-06 0 9.66e-06 3.3 9.699e-06 3.3 9.7e-06 0 9.739e-06 0 9.74e-06 3.3 9.759e-06 3.3 9.76e-06 0 9.779e-06 0 9.78e-06 3.3 9.819e-06 3.3 9.82e-06 0 9.859e-06 0 9.86e-06 3.3 9.919e-06 3.3 9.92e-06 0 9.939e-06 0 9.94e-06 3.3 9.979e-06 3.3 9.98e-06 0 9.999e-06 0 1e-05 3.3 1.0119e-05 3.3 1.012e-05 0 1.0139e-05 0 1.014e-05 3.3 1.0199e-05 3.3 1.02e-05 0 1.0359e-05 0 1.036e-05 3.3 1.0379e-05 3.3 1.038e-05 0 1.0399e-05 0 1.04e-05 3.3 1.0479e-05 3.3 1.048e-05 0 1.0499e-05 0 1.05e-05 3.3 1.0539e-05 3.3 1.054e-05 0 1.0599e-05 0 1.06e-05 3.3 1.0619e-05 3.3 1.062e-05 0 1.0639e-05 0 1.064e-05 3.3 1.0659e-05 3.3 1.066e-05 0 1.0679e-05 0 1.068e-05 3.3 1.0699e-05 3.3 1.07e-05 0 1.0719e-05 0 1.072e-05 3.3 1.0759e-05 3.3 1.076e-05 0 1.0779e-05 0 1.078e-05 3.3 1.0819e-05 3.3 1.082e-05 0 1.0899e-05 0 1.09e-05 3.3 1.0919e-05 3.3 1.092e-05 0 1.0959e-05 0 1.096e-05 3.3 1.0999e-05 3.3 1.1e-05 0 1.1019e-05 0 1.102e-05 3.3 1.1039e-05 3.3 1.104e-05 0 1.1059e-05 0 1.106e-05 3.3 1.1079e-05 3.3 1.108e-05 0 1.1099e-05 0 1.11e-05 3.3 1.1139e-05 3.3 1.114e-05 0 1.1179e-05 0 1.118e-05 3.3 1.1199e-05 3.3 1.12e-05 0 1.1279e-05 0 1.128e-05 3.3 1.1299e-05 3.3 1.13e-05 0 1.1319e-05 0 1.132e-05 3.3 1.1339e-05 3.3 1.134e-05 0 1.1359e-05 0 1.136e-05 3.3 1.1379e-05 3.3 1.138e-05 0 1.1399e-05 0 1.14e-05 3.3 1.1419e-05 3.3 1.142e-05 0 1.1459e-05 0 1.146e-05 3.3 1.1479e-05 3.3 1.148e-05 0 1.1519e-05 0 1.152e-05 3.3 1.1539e-05 3.3 1.154e-05 0 1.1559e-05 0 1.156e-05 3.3 1.1579e-05 3.3 1.158e-05 0 1.1619e-05 0 1.162e-05 3.3 1.1699e-05 3.3 1.17e-05 0 1.1739e-05 0 1.174e-05 3.3 1.1799e-05 3.3 1.18e-05 0 1.1879e-05 0 1.188e-05 3.3 1.1899e-05 3.3 1.19e-05 0 1.1939e-05 0 1.194e-05 3.3 1.1979e-05 3.3 1.198e-05 0 1.1999e-05 0 1.2e-05 3.3 1.2059e-05 3.3 1.206e-05 0 1.2179e-05 0 1.218e-05 3.3 1.2199e-05 3.3 1.22e-05 0 1.2219e-05 0 1.222e-05 3.3 1.2239e-05 3.3 1.224e-05 0 1.2279e-05 0 1.228e-05 3.3 1.2319e-05 3.3 1.232e-05 0 1.2359e-05 0 1.236e-05 3.3 1.2419e-05 3.3 1.242e-05 0 1.2479e-05 0 1.248e-05 3.3 1.2499e-05 3.3 1.25e-05 0 1.2519e-05 0 1.252e-05 3.3 1.2639e-05 3.3 1.264e-05 0 1.2659e-05 0 1.266e-05 3.3 1.2699e-05 3.3 1.27e-05 0 1.2739e-05 0 1.274e-05 3.3 1.2759e-05 3.3 1.276e-05 0 1.2779e-05 0 1.278e-05 3.3 1.2799e-05 3.3 1.28e-05 0 1.2859e-05 0 1.286e-05 3.3 1.2899e-05 3.3 1.29e-05 0 1.2919e-05 0 1.292e-05 3.3 1.2939e-05 3.3 1.294e-05 0 1.2959e-05 0 1.296e-05 3.3 1.2979e-05 3.3 1.298e-05 0 1.3019e-05 0 1.302e-05 3.3 1.3059e-05 3.3 1.306e-05 0 1.3099e-05 0 1.31e-05 3.3 1.3119e-05 3.3 1.312e-05 0 1.3179e-05 0 1.318e-05 3.3 1.3199e-05 3.3 1.32e-05 0 1.3239e-05 0 1.324e-05 3.3 1.3279e-05 3.3 1.328e-05 0 1.3299e-05 0 1.33e-05 3.3 1.3339e-05 3.3 1.334e-05 0 1.3359e-05 0 1.336e-05 3.3 1.3399e-05 3.3 1.34e-05 0 1.3419e-05 0 1.342e-05 3.3 1.3439e-05 3.3 1.344e-05 0 1.3499e-05 0 1.35e-05 3.3 1.3519e-05 3.3 1.352e-05 0 1.3579e-05 0 1.358e-05 3.3 1.3599e-05 3.3 1.36e-05 0 1.3619e-05 0 1.362e-05 3.3 1.3659e-05 3.3 1.366e-05 0 1.3679e-05 0 1.368e-05 3.3 1.3719e-05 3.3 1.372e-05 0 1.3739e-05 0 1.374e-05 3.3 1.3759e-05 3.3 1.376e-05 0 1.3779e-05 0 1.378e-05 3.3 1.3799e-05 3.3 1.38e-05 0 1.3859e-05 0 1.386e-05 3.3 1.3879e-05 3.3 1.388e-05 0 1.3959e-05 0 1.396e-05 3.3 1.4019e-05 3.3 1.402e-05 0 1.4039e-05 0 1.404e-05 3.3 1.4059e-05 3.3 1.406e-05 0 1.4099e-05 0 1.41e-05 3.3 1.4119e-05 3.3 1.412e-05 0 1.4159e-05 0 1.416e-05 3.3 1.4179e-05 3.3 1.418e-05 0 1.4219e-05 0 1.422e-05 3.3 1.4299e-05 3.3 1.43e-05 0 1.4339e-05 0 1.434e-05 3.3 1.4359e-05 3.3 1.436e-05 0 1.4379e-05 0 1.438e-05 3.3 1.4439e-05 3.3 1.444e-05 0 1.4459e-05 0 1.446e-05 3.3 1.4479e-05 3.3 1.448e-05 0 1.4499e-05 0 1.45e-05 3.3 1.4519e-05 3.3 1.452e-05 0 1.4539e-05 0 1.454e-05 3.3 1.4699e-05 3.3 1.47e-05 0 1.4739e-05 0 1.474e-05 3.3 1.4759e-05 3.3 1.476e-05 0 1.4779e-05 0 1.478e-05 3.3 1.4819e-05 3.3 1.482e-05 0 1.4919e-05 0 1.492e-05 3.3 1.4979e-05 3.3 1.498e-05 0 1.5019e-05 0 1.502e-05 3.3 1.5059e-05 3.3 1.506e-05 0 1.5119e-05 0 1.512e-05 3.3 1.5159e-05 3.3 1.516e-05 0 1.5199e-05 0 1.52e-05 3.3 1.5259e-05 3.3 1.526e-05 0 1.5279e-05 0 1.528e-05 3.3 1.5299e-05 3.3 1.53e-05 0 1.5319e-05 0 1.532e-05 3.3 1.5339e-05 3.3 1.534e-05 0 1.5379e-05 0 1.538e-05 3.3 1.5399e-05 3.3 1.54e-05 0 1.5459e-05 0 1.546e-05 3.3 1.5479e-05 3.3 1.548e-05 0 1.5519e-05 0 1.552e-05 3.3 1.5559e-05 3.3 1.556e-05 0 1.5579e-05 0 1.558e-05 3.3 1.5599e-05 3.3 1.56e-05 0 1.5679e-05 0 1.568e-05 3.3 1.5699e-05 3.3 1.57e-05 0 1.5739e-05 0 1.574e-05 3.3 1.5839e-05 3.3 1.584e-05 0 1.5959e-05 0 1.596e-05 3.3 1.6e-05 3.3)
V3 B_6_2[2] GND PWL(0 3.3 9.9e-08 3.3 1e-07 0 1.39e-07 0 1.4e-07 3.3 1.59e-07 3.3 1.6e-07 0 1.99e-07 0 2e-07 3.3 2.39e-07 3.3 2.4e-07 0 2.59e-07 0 2.6e-07 3.3 2.79e-07 3.3 2.8e-07 0 2.99e-07 0 3e-07 3.3 3.59e-07 3.3 3.6e-07 0 3.79e-07 0 3.8e-07 3.3 4.39e-07 3.3 4.4e-07 0 5.19e-07 0 5.2e-07 3.3 5.39e-07 3.3 5.4e-07 0 5.59e-07 0 5.6e-07 3.3 5.99e-07 3.3 6e-07 0 7.19e-07 0 7.2e-07 3.3 7.59e-07 3.3 7.6e-07 0 7.99e-07 0 8e-07 3.3 8.39e-07 3.3 8.4e-07 0 8.99e-07 0 9e-07 3.3 9.39e-07 3.3 9.4e-07 0 9.59e-07 0 9.6e-07 3.3 9.79e-07 3.3 9.8e-07 0 9.99e-07 0 1e-06 3.3 1.019e-06 3.3 1.02e-06 0 1.059e-06 0 1.06e-06 3.3 1.239e-06 3.3 1.24e-06 0 1.299e-06 0 1.3e-06 3.3 1.339e-06 3.3 1.34e-06 0 1.359e-06 0 1.36e-06 3.3 1.379e-06 3.3 1.38e-06 0 1.399e-06 0 1.4e-06 3.3 1.419e-06 3.3 1.42e-06 0 1.499e-06 0 1.5e-06 3.3 1.579e-06 3.3 1.58e-06 0 1.599e-06 0 1.6e-06 3.3 1.619e-06 3.3 1.62e-06 0 1.699e-06 0 1.7e-06 3.3 1.759e-06 3.3 1.76e-06 0 1.859e-06 0 1.86e-06 3.3 1.939e-06 3.3 1.94e-06 0 1.959e-06 0 1.96e-06 3.3 1.999e-06 3.3 2e-06 0 2.019e-06 0 2.02e-06 3.3 2.039e-06 3.3 2.04e-06 0 2.059e-06 0 2.06e-06 3.3 2.079e-06 3.3 2.08e-06 0 2.099e-06 0 2.1e-06 3.3 2.119e-06 3.3 2.12e-06 0 2.199e-06 0 2.2e-06 3.3 2.239e-06 3.3 2.24e-06 0 2.379e-06 0 2.38e-06 3.3 2.419e-06 3.3 2.42e-06 0 2.519e-06 0 2.52e-06 3.3 2.539e-06 3.3 2.54e-06 0 2.559e-06 0 2.56e-06 3.3 2.579e-06 3.3 2.58e-06 0 2.619e-06 0 2.62e-06 3.3 2.659e-06 3.3 2.66e-06 0 2.699e-06 0 2.7e-06 3.3 2.759e-06 3.3 2.76e-06 0 2.779e-06 0 2.78e-06 3.3 2.799e-06 3.3 2.8e-06 0 2.819e-06 0 2.82e-06 3.3 2.839e-06 3.3 2.84e-06 0 2.899e-06 0 2.9e-06 3.3 2.959e-06 3.3 2.96e-06 0 3.019e-06 0 3.02e-06 3.3 3.099e-06 3.3 3.1e-06 0 3.119e-06 0 3.12e-06 3.3 3.139e-06 3.3 3.14e-06 0 3.219e-06 0 3.22e-06 3.3 3.239e-06 3.3 3.24e-06 0 3.259e-06 0 3.26e-06 3.3 3.279e-06 3.3 3.28e-06 0 3.319e-06 0 3.32e-06 3.3 3.359e-06 3.3 3.36e-06 0 3.379e-06 0 3.38e-06 3.3 3.459e-06 3.3 3.46e-06 0 3.479e-06 0 3.48e-06 3.3 3.519e-06 3.3 3.52e-06 0 3.559e-06 0 3.56e-06 3.3 3.599e-06 3.3 3.6e-06 0 3.619e-06 0 3.62e-06 3.3 3.639e-06 3.3 3.64e-06 0 3.659e-06 0 3.66e-06 3.3 3.679e-06 3.3 3.68e-06 0 3.699e-06 0 3.7e-06 3.3 3.759e-06 3.3 3.76e-06 0 3.799e-06 0 3.8e-06 3.3 3.839e-06 3.3 3.84e-06 0 3.879e-06 0 3.88e-06 3.3 3.939e-06 3.3 3.94e-06 0 3.999e-06 0 4e-06 3.3 4.039e-06 3.3 4.04e-06 0 4.059e-06 0 4.06e-06 3.3 4.119e-06 3.3 4.12e-06 0 4.199e-06 0 4.2e-06 3.3 4.239e-06 3.3 4.24e-06 0 4.259e-06 0 4.26e-06 3.3 4.299e-06 3.3 4.3e-06 0 4.319e-06 0 4.32e-06 3.3 4.359e-06 3.3 4.36e-06 0 4.399e-06 0 4.4e-06 3.3 4.459e-06 3.3 4.46e-06 0 4.499e-06 0 4.5e-06 3.3 4.679e-06 3.3 4.68e-06 0 4.699e-06 0 4.7e-06 3.3 4.779e-06 3.3 4.78e-06 0 4.819e-06 0 4.82e-06 3.3 4.839e-06 3.3 4.84e-06 0 4.859e-06 0 4.86e-06 3.3 4.879e-06 3.3 4.88e-06 0 4.919e-06 0 4.92e-06 3.3 4.959e-06 3.3 4.96e-06 0 5.019e-06 0 5.02e-06 3.3 5.039e-06 3.3 5.04e-06 0 5.059e-06 0 5.06e-06 3.3 5.079e-06 3.3 5.08e-06 0 5.099e-06 0 5.1e-06 3.3 5.119e-06 3.3 5.12e-06 0 5.199e-06 0 5.2e-06 3.3 5.279e-06 3.3 5.28e-06 0 5.319e-06 0 5.32e-06 3.3 5.339e-06 3.3 5.34e-06 0 5.359e-06 0 5.36e-06 3.3 5.459e-06 3.3 5.46e-06 0 5.479e-06 0 5.48e-06 3.3 5.499e-06 3.3 5.5e-06 0 5.519e-06 0 5.52e-06 3.3 5.539e-06 3.3 5.54e-06 0 5.559e-06 0 5.56e-06 3.3 5.599e-06 3.3 5.6e-06 0 5.619e-06 0 5.62e-06 3.3 5.639e-06 3.3 5.64e-06 0 5.719e-06 0 5.72e-06 3.3 5.759e-06 3.3 5.76e-06 0 5.799e-06 0 5.8e-06 3.3 5.839e-06 3.3 5.84e-06 0 5.879e-06 0 5.88e-06 3.3 5.899e-06 3.3 5.9e-06 0 5.919e-06 0 5.92e-06 3.3 5.959e-06 3.3 5.96e-06 0 6.039e-06 0 6.04e-06 3.3 6.119e-06 3.3 6.12e-06 0 6.179e-06 0 6.18e-06 3.3 6.299e-06 3.3 6.3e-06 0 6.379e-06 0 6.38e-06 3.3 6.459e-06 3.3 6.46e-06 0 6.499e-06 0 6.5e-06 3.3 6.539e-06 3.3 6.54e-06 0 6.559e-06 0 6.56e-06 3.3 6.659e-06 3.3 6.66e-06 0 6.739e-06 0 6.74e-06 3.3 6.779e-06 3.3 6.78e-06 0 6.919e-06 0 6.92e-06 3.3 6.939e-06 3.3 6.94e-06 0 6.979e-06 0 6.98e-06 3.3 7.079e-06 3.3 7.08e-06 0 7.099e-06 0 7.1e-06 3.3 7.139e-06 3.3 7.14e-06 0 7.159e-06 0 7.16e-06 3.3 7.179e-06 3.3 7.18e-06 0 7.219e-06 0 7.22e-06 3.3 7.279e-06 3.3 7.28e-06 0 7.319e-06 0 7.32e-06 3.3 7.359e-06 3.3 7.36e-06 0 7.379e-06 0 7.38e-06 3.3 7.459e-06 3.3 7.46e-06 0 7.519e-06 0 7.52e-06 3.3 7.539e-06 3.3 7.54e-06 0 7.559e-06 0 7.56e-06 3.3 7.599e-06 3.3 7.6e-06 0 7.619e-06 0 7.62e-06 3.3 7.639e-06 3.3 7.64e-06 0 7.679e-06 0 7.68e-06 3.3 7.699e-06 3.3 7.7e-06 0 7.719e-06 0 7.72e-06 3.3 7.759e-06 3.3 7.76e-06 0 7.779e-06 0 7.78e-06 3.3 7.799e-06 3.3 7.8e-06 0 7.819e-06 0 7.82e-06 3.3 7.859e-06 3.3 7.86e-06 0 7.879e-06 0 7.88e-06 3.3 7.899e-06 3.3 7.9e-06 0 7.919e-06 0 7.92e-06 3.3 7.979e-06 3.3 7.98e-06 0 7.999e-06 0 8e-06 3.3 8.099e-06 3.3 8.1e-06 0 8.139e-06 0 8.14e-06 3.3 8.159e-06 3.3 8.16e-06 0 8.199e-06 0 8.2e-06 3.3 8.239e-06 3.3 8.24e-06 0 8.259e-06 0 8.26e-06 3.3 8.279e-06 3.3 8.28e-06 0 8.299e-06 0 8.3e-06 3.3 8.359e-06 3.3 8.36e-06 0 8.379e-06 0 8.38e-06 3.3 8.439e-06 3.3 8.44e-06 0 8.519e-06 0 8.52e-06 3.3 8.539e-06 3.3 8.54e-06 0 8.559e-06 0 8.56e-06 3.3 8.599e-06 3.3 8.6e-06 0 8.719e-06 0 8.72e-06 3.3 8.759e-06 3.3 8.76e-06 0 8.799e-06 0 8.8e-06 3.3 8.839e-06 3.3 8.84e-06 0 8.899e-06 0 8.9e-06 3.3 8.939e-06 3.3 8.94e-06 0 8.959e-06 0 8.96e-06 3.3 8.979e-06 3.3 8.98e-06 0 8.999e-06 0 9e-06 3.3 9.019e-06 3.3 9.02e-06 0 9.059e-06 0 9.06e-06 3.3 9.239e-06 3.3 9.24e-06 0 9.299e-06 0 9.3e-06 3.3 9.339e-06 3.3 9.34e-06 0 9.359e-06 0 9.36e-06 3.3 9.379e-06 3.3 9.38e-06 0 9.399e-06 0 9.4e-06 3.3 9.419e-06 3.3 9.42e-06 0 9.499e-06 0 9.5e-06 3.3 9.579e-06 3.3 9.58e-06 0 9.599e-06 0 9.6e-06 3.3 9.619e-06 3.3 9.62e-06 0 9.699e-06 0 9.7e-06 3.3 9.759e-06 3.3 9.76e-06 0 9.859e-06 0 9.86e-06 3.3 9.939e-06 3.3 9.94e-06 0 9.959e-06 0 9.96e-06 3.3 9.999e-06 3.3 1e-05 0 1.0019e-05 0 1.002e-05 3.3 1.0039e-05 3.3 1.004e-05 0 1.0059e-05 0 1.006e-05 3.3 1.0079e-05 3.3 1.008e-05 0 1.0099e-05 0 1.01e-05 3.3 1.0119e-05 3.3 1.012e-05 0 1.0199e-05 0 1.02e-05 3.3 1.0239e-05 3.3 1.024e-05 0 1.0379e-05 0 1.038e-05 3.3 1.0419e-05 3.3 1.042e-05 0 1.0519e-05 0 1.052e-05 3.3 1.0539e-05 3.3 1.054e-05 0 1.0559e-05 0 1.056e-05 3.3 1.0579e-05 3.3 1.058e-05 0 1.0619e-05 0 1.062e-05 3.3 1.0659e-05 3.3 1.066e-05 0 1.0699e-05 0 1.07e-05 3.3 1.0759e-05 3.3 1.076e-05 0 1.0779e-05 0 1.078e-05 3.3 1.0799e-05 3.3 1.08e-05 0 1.0819e-05 0 1.082e-05 3.3 1.0839e-05 3.3 1.084e-05 0 1.0899e-05 0 1.09e-05 3.3 1.0959e-05 3.3 1.096e-05 0 1.1019e-05 0 1.102e-05 3.3 1.1099e-05 3.3 1.11e-05 0 1.1119e-05 0 1.112e-05 3.3 1.1139e-05 3.3 1.114e-05 0 1.1219e-05 0 1.122e-05 3.3 1.1239e-05 3.3 1.124e-05 0 1.1259e-05 0 1.126e-05 3.3 1.1279e-05 3.3 1.128e-05 0 1.1319e-05 0 1.132e-05 3.3 1.1359e-05 3.3 1.136e-05 0 1.1379e-05 0 1.138e-05 3.3 1.1459e-05 3.3 1.146e-05 0 1.1479e-05 0 1.148e-05 3.3 1.1519e-05 3.3 1.152e-05 0 1.1559e-05 0 1.156e-05 3.3 1.1599e-05 3.3 1.16e-05 0 1.1619e-05 0 1.162e-05 3.3 1.1639e-05 3.3 1.164e-05 0 1.1659e-05 0 1.166e-05 3.3 1.1679e-05 3.3 1.168e-05 0 1.1699e-05 0 1.17e-05 3.3 1.1759e-05 3.3 1.176e-05 0 1.1799e-05 0 1.18e-05 3.3 1.1839e-05 3.3 1.184e-05 0 1.1879e-05 0 1.188e-05 3.3 1.1939e-05 3.3 1.194e-05 0 1.1999e-05 0 1.2e-05 3.3 1.2039e-05 3.3 1.204e-05 0 1.2059e-05 0 1.206e-05 3.3 1.2119e-05 3.3 1.212e-05 0 1.2199e-05 0 1.22e-05 3.3 1.2239e-05 3.3 1.224e-05 0 1.2259e-05 0 1.226e-05 3.3 1.2299e-05 3.3 1.23e-05 0 1.2319e-05 0 1.232e-05 3.3 1.2359e-05 3.3 1.236e-05 0 1.2399e-05 0 1.24e-05 3.3 1.2459e-05 3.3 1.246e-05 0 1.2499e-05 0 1.25e-05 3.3 1.2679e-05 3.3 1.268e-05 0 1.2699e-05 0 1.27e-05 3.3 1.2779e-05 3.3 1.278e-05 0 1.2819e-05 0 1.282e-05 3.3 1.2839e-05 3.3 1.284e-05 0 1.2859e-05 0 1.286e-05 3.3 1.2879e-05 3.3 1.288e-05 0 1.2919e-05 0 1.292e-05 3.3 1.2959e-05 3.3 1.296e-05 0 1.3019e-05 0 1.302e-05 3.3 1.3039e-05 3.3 1.304e-05 0 1.3059e-05 0 1.306e-05 3.3 1.3079e-05 3.3 1.308e-05 0 1.3099e-05 0 1.31e-05 3.3 1.3119e-05 3.3 1.312e-05 0 1.3199e-05 0 1.32e-05 3.3 1.3279e-05 3.3 1.328e-05 0 1.3319e-05 0 1.332e-05 3.3 1.3339e-05 3.3 1.334e-05 0 1.3359e-05 0 1.336e-05 3.3 1.3459e-05 3.3 1.346e-05 0 1.3479e-05 0 1.348e-05 3.3 1.3499e-05 3.3 1.35e-05 0 1.3519e-05 0 1.352e-05 3.3 1.3539e-05 3.3 1.354e-05 0 1.3559e-05 0 1.356e-05 3.3 1.3599e-05 3.3 1.36e-05 0 1.3619e-05 0 1.362e-05 3.3 1.3639e-05 3.3 1.364e-05 0 1.3719e-05 0 1.372e-05 3.3 1.3759e-05 3.3 1.376e-05 0 1.3799e-05 0 1.38e-05 3.3 1.3839e-05 3.3 1.384e-05 0 1.3879e-05 0 1.388e-05 3.3 1.3899e-05 3.3 1.39e-05 0 1.3919e-05 0 1.392e-05 3.3 1.3959e-05 3.3 1.396e-05 0 1.4039e-05 0 1.404e-05 3.3 1.4119e-05 3.3 1.412e-05 0 1.4179e-05 0 1.418e-05 3.3 1.4299e-05 3.3 1.43e-05 0 1.4379e-05 0 1.438e-05 3.3 1.4459e-05 3.3 1.446e-05 0 1.4499e-05 0 1.45e-05 3.3 1.4539e-05 3.3 1.454e-05 0 1.4559e-05 0 1.456e-05 3.3 1.4659e-05 3.3 1.466e-05 0 1.4739e-05 0 1.474e-05 3.3 1.4779e-05 3.3 1.478e-05 0 1.4919e-05 0 1.492e-05 3.3 1.4939e-05 3.3 1.494e-05 0 1.4979e-05 0 1.498e-05 3.3 1.5079e-05 3.3 1.508e-05 0 1.5099e-05 0 1.51e-05 3.3 1.5139e-05 3.3 1.514e-05 0 1.5159e-05 0 1.516e-05 3.3 1.5179e-05 3.3 1.518e-05 0 1.5219e-05 0 1.522e-05 3.3 1.5279e-05 3.3 1.528e-05 0 1.5319e-05 0 1.532e-05 3.3 1.5359e-05 3.3 1.536e-05 0 1.5379e-05 0 1.538e-05 3.3 1.5459e-05 3.3 1.546e-05 0 1.5519e-05 0 1.552e-05 3.3 1.5539e-05 3.3 1.554e-05 0 1.5559e-05 0 1.556e-05 3.3 1.5599e-05 3.3 1.56e-05 0 1.5619e-05 0 1.562e-05 3.3 1.5639e-05 3.3 1.564e-05 0 1.5679e-05 0 1.568e-05 3.3 1.5699e-05 3.3 1.57e-05 0 1.5719e-05 0 1.572e-05 3.3 1.5759e-05 3.3 1.576e-05 0 1.5779e-05 0 1.578e-05 3.3 1.5799e-05 3.3 1.58e-05 0 1.5819e-05 0 1.582e-05 3.3 1.5859e-05 3.3 1.586e-05 0 1.5879e-05 0 1.588e-05 3.3 1.5899e-05 3.3 1.59e-05 0 1.5919e-05 0 1.592e-05 3.3 1.5979e-05 3.3 1.598e-05 0 1.6e-05 0)
V4 B_6_2[3] GND PWL(0 3.3 1.39e-07 3.3 1.4e-07 0 1.99e-07 0 2e-07 3.3 2.19e-07 3.3 2.2e-07 0 2.59e-07 0 2.6e-07 3.3 2.79e-07 3.3 2.8e-07 0 2.99e-07 0 3e-07 3.3 3.39e-07 3.3 3.4e-07 0 3.59e-07 0 3.6e-07 3.3 3.99e-07 3.3 4e-07 0 4.19e-07 0 4.2e-07 3.3 4.39e-07 3.3 4.4e-07 0 4.59e-07 0 4.6e-07 3.3 4.79e-07 3.3 4.8e-07 0 4.99e-07 0 5e-07 3.3 5.39e-07 3.3 5.4e-07 0 5.59e-07 0 5.6e-07 3.3 5.79e-07 3.3 5.8e-07 0 6.39e-07 0 6.4e-07 3.3 6.59e-07 3.3 6.6e-07 0 6.79e-07 0 6.8e-07 3.3 6.99e-07 3.3 7e-07 0 7.19e-07 0 7.2e-07 3.3 7.39e-07 3.3 7.4e-07 0 7.79e-07 0 7.8e-07 3.3 7.99e-07 3.3 8e-07 0 8.19e-07 0 8.2e-07 3.3 8.39e-07 3.3 8.4e-07 0 8.59e-07 0 8.6e-07 3.3 9.19e-07 3.3 9.2e-07 0 9.39e-07 0 9.4e-07 3.3 9.79e-07 3.3 9.8e-07 0 1.019e-06 0 1.02e-06 3.3 1.139e-06 3.3 1.14e-06 0 1.199e-06 0 1.2e-06 3.3 1.219e-06 3.3 1.22e-06 0 1.279e-06 0 1.28e-06 3.3 1.339e-06 3.3 1.34e-06 0 1.379e-06 0 1.38e-06 3.3 1.419e-06 3.3 1.42e-06 0 1.439e-06 0 1.44e-06 3.3 1.479e-06 3.3 1.48e-06 0 1.519e-06 0 1.52e-06 3.3 1.559e-06 3.3 1.56e-06 0 1.579e-06 0 1.58e-06 3.3 1.599e-06 3.3 1.6e-06 0 1.639e-06 0 1.64e-06 3.3 1.659e-06 3.3 1.66e-06 0 1.679e-06 0 1.68e-06 3.3 1.699e-06 3.3 1.7e-06 0 1.719e-06 0 1.72e-06 3.3 1.739e-06 3.3 1.74e-06 0 1.779e-06 0 1.78e-06 3.3 1.799e-06 3.3 1.8e-06 0 1.839e-06 0 1.84e-06 3.3 1.859e-06 3.3 1.86e-06 0 1.899e-06 0 1.9e-06 3.3 1.919e-06 3.3 1.92e-06 0 1.939e-06 0 1.94e-06 3.3 1.979e-06 3.3 1.98e-06 0 1.999e-06 0 2e-06 3.3 2.039e-06 3.3 2.04e-06 0 2.079e-06 0 2.08e-06 3.3 2.179e-06 3.3 2.18e-06 0 2.199e-06 0 2.2e-06 3.3 2.219e-06 3.3 2.22e-06 0 2.459e-06 0 2.46e-06 3.3 2.479e-06 3.3 2.48e-06 0 2.499e-06 0 2.5e-06 3.3 2.599e-06 3.3 2.6e-06 0 2.619e-06 0 2.62e-06 3.3 2.639e-06 3.3 2.64e-06 0 2.679e-06 0 2.68e-06 3.3 2.699e-06 3.3 2.7e-06 0 2.719e-06 0 2.72e-06 3.3 2.739e-06 3.3 2.74e-06 0 2.879e-06 0 2.88e-06 3.3 2.919e-06 3.3 2.92e-06 0 2.939e-06 0 2.94e-06 3.3 2.959e-06 3.3 2.96e-06 0 2.979e-06 0 2.98e-06 3.3 2.999e-06 3.3 3e-06 0 3.039e-06 0 3.04e-06 3.3 3.059e-06 3.3 3.06e-06 0 3.079e-06 0 3.08e-06 3.3 3.139e-06 3.3 3.14e-06 0 3.159e-06 0 3.16e-06 3.3 3.179e-06 3.3 3.18e-06 0 3.199e-06 0 3.2e-06 3.3 3.219e-06 3.3 3.22e-06 0 3.259e-06 0 3.26e-06 3.3 3.319e-06 3.3 3.32e-06 0 3.399e-06 0 3.4e-06 3.3 3.439e-06 3.3 3.44e-06 0 3.459e-06 0 3.46e-06 3.3 3.479e-06 3.3 3.48e-06 0 3.499e-06 0 3.5e-06 3.3 3.559e-06 3.3 3.56e-06 0 3.619e-06 0 3.62e-06 3.3 3.659e-06 3.3 3.66e-06 0 3.719e-06 0 3.72e-06 3.3 3.739e-06 3.3 3.74e-06 0 3.759e-06 0 3.76e-06 3.3 3.779e-06 3.3 3.78e-06 0 3.819e-06 0 3.82e-06 3.3 3.859e-06 3.3 3.86e-06 0 3.899e-06 0 3.9e-06 3.3 3.919e-06 3.3 3.92e-06 0 3.939e-06 0 3.94e-06 3.3 3.959e-06 3.3 3.96e-06 0 3.979e-06 0 3.98e-06 3.3 4.019e-06 3.3 4.02e-06 0 4.059e-06 0 4.06e-06 3.3 4.099e-06 3.3 4.1e-06 0 4.119e-06 0 4.12e-06 3.3 4.139e-06 3.3 4.14e-06 0 4.159e-06 0 4.16e-06 3.3 4.179e-06 3.3 4.18e-06 0 4.199e-06 0 4.2e-06 3.3 4.219e-06 3.3 4.22e-06 0 4.259e-06 0 4.26e-06 3.3 4.279e-06 3.3 4.28e-06 0 4.319e-06 0 4.32e-06 3.3 4.339e-06 3.3 4.34e-06 0 4.379e-06 0 4.38e-06 3.3 4.399e-06 3.3 4.4e-06 0 4.419e-06 0 4.42e-06 3.3 4.439e-06 3.3 4.44e-06 0 4.479e-06 0 4.48e-06 3.3 4.659e-06 3.3 4.66e-06 0 4.679e-06 0 4.68e-06 3.3 4.699e-06 3.3 4.7e-06 0 4.719e-06 0 4.72e-06 3.3 4.759e-06 3.3 4.76e-06 0 4.799e-06 0 4.8e-06 3.3 4.839e-06 3.3 4.84e-06 0 4.879e-06 0 4.88e-06 3.3 4.899e-06 3.3 4.9e-06 0 4.939e-06 0 4.94e-06 3.3 4.959e-06 3.3 4.96e-06 0 4.979e-06 0 4.98e-06 3.3 4.999e-06 3.3 5e-06 0 5.019e-06 0 5.02e-06 3.3 5.139e-06 3.3 5.14e-06 0 5.159e-06 0 5.16e-06 3.3 5.179e-06 3.3 5.18e-06 0 5.199e-06 0 5.2e-06 3.3 5.219e-06 3.3 5.22e-06 0 5.239e-06 0 5.24e-06 3.3 5.259e-06 3.3 5.26e-06 0 5.379e-06 0 5.38e-06 3.3 5.399e-06 3.3 5.4e-06 0 5.419e-06 0 5.42e-06 3.3 5.459e-06 3.3 5.46e-06 0 5.499e-06 0 5.5e-06 3.3 5.539e-06 3.3 5.54e-06 0 5.599e-06 0 5.6e-06 3.3 5.659e-06 3.3 5.66e-06 0 5.679e-06 0 5.68e-06 3.3 5.699e-06 3.3 5.7e-06 0 5.839e-06 0 5.84e-06 3.3 5.899e-06 3.3 5.9e-06 0 5.939e-06 0 5.94e-06 3.3 5.959e-06 3.3 5.96e-06 0 5.979e-06 0 5.98e-06 3.3 6.079e-06 3.3 6.08e-06 0 6.099e-06 0 6.1e-06 3.3 6.139e-06 3.3 6.14e-06 0 6.159e-06 0 6.16e-06 3.3 6.179e-06 3.3 6.18e-06 0 6.199e-06 0 6.2e-06 3.3 6.219e-06 3.3 6.22e-06 0 6.239e-06 0 6.24e-06 3.3 6.259e-06 3.3 6.26e-06 0 6.299e-06 0 6.3e-06 3.3 6.319e-06 3.3 6.32e-06 0 6.359e-06 0 6.36e-06 3.3 6.399e-06 3.3 6.4e-06 0 6.419e-06 0 6.42e-06 3.3 6.439e-06 3.3 6.44e-06 0 6.459e-06 0 6.46e-06 3.3 6.479e-06 3.3 6.48e-06 0 6.519e-06 0 6.52e-06 3.3 6.539e-06 3.3 6.54e-06 0 6.599e-06 0 6.6e-06 3.3 6.639e-06 3.3 6.64e-06 0 6.679e-06 0 6.68e-06 3.3 6.739e-06 3.3 6.74e-06 0 6.939e-06 0 6.94e-06 3.3 6.959e-06 3.3 6.96e-06 0 7.019e-06 0 7.02e-06 3.3 7.099e-06 3.3 7.1e-06 0 7.119e-06 0 7.12e-06 3.3 7.159e-06 3.3 7.16e-06 0 7.199e-06 0 7.2e-06 3.3 7.219e-06 3.3 7.22e-06 0 7.239e-06 0 7.24e-06 3.3 7.299e-06 3.3 7.3e-06 0 7.319e-06 0 7.32e-06 3.3 7.339e-06 3.3 7.34e-06 0 7.359e-06 0 7.36e-06 3.3 7.399e-06 3.3 7.4e-06 0 7.419e-06 0 7.42e-06 3.3 7.439e-06 3.3 7.44e-06 0 7.459e-06 0 7.46e-06 3.3 7.479e-06 3.3 7.48e-06 0 7.499e-06 0 7.5e-06 3.3 7.539e-06 3.3 7.54e-06 0 7.579e-06 0 7.58e-06 3.3 7.599e-06 3.3 7.6e-06 0 7.619e-06 0 7.62e-06 3.3 7.659e-06 3.3 7.66e-06 0 7.679e-06 0 7.68e-06 3.3 7.719e-06 3.3 7.72e-06 0 7.739e-06 0 7.74e-06 3.3 7.779e-06 3.3 7.78e-06 0 7.819e-06 0 7.82e-06 3.3 7.859e-06 3.3 7.86e-06 0 7.879e-06 0 7.88e-06 3.3 7.899e-06 3.3 7.9e-06 0 7.939e-06 0 7.94e-06 3.3 7.979e-06 3.3 7.98e-06 0 7.999e-06 0 8e-06 3.3 8.139e-06 3.3 8.14e-06 0 8.199e-06 0 8.2e-06 3.3 8.219e-06 3.3 8.22e-06 0 8.259e-06 0 8.26e-06 3.3 8.279e-06 3.3 8.28e-06 0 8.299e-06 0 8.3e-06 3.3 8.339e-06 3.3 8.34e-06 0 8.359e-06 0 8.36e-06 3.3 8.399e-06 3.3 8.4e-06 0 8.419e-06 0 8.42e-06 3.3 8.439e-06 3.3 8.44e-06 0 8.459e-06 0 8.46e-06 3.3 8.479e-06 3.3 8.48e-06 0 8.499e-06 0 8.5e-06 3.3 8.539e-06 3.3 8.54e-06 0 8.559e-06 0 8.56e-06 3.3 8.579e-06 3.3 8.58e-06 0 8.639e-06 0 8.64e-06 3.3 8.659e-06 3.3 8.66e-06 0 8.679e-06 0 8.68e-06 3.3 8.699e-06 3.3 8.7e-06 0 8.719e-06 0 8.72e-06 3.3 8.739e-06 3.3 8.74e-06 0 8.779e-06 0 8.78e-06 3.3 8.799e-06 3.3 8.8e-06 0 8.819e-06 0 8.82e-06 3.3 8.839e-06 3.3 8.84e-06 0 8.859e-06 0 8.86e-06 3.3 8.919e-06 3.3 8.92e-06 0 8.939e-06 0 8.94e-06 3.3 8.979e-06 3.3 8.98e-06 0 9.019e-06 0 9.02e-06 3.3 9.139e-06 3.3 9.14e-06 0 9.199e-06 0 9.2e-06 3.3 9.219e-06 3.3 9.22e-06 0 9.279e-06 0 9.28e-06 3.3 9.339e-06 3.3 9.34e-06 0 9.379e-06 0 9.38e-06 3.3 9.419e-06 3.3 9.42e-06 0 9.439e-06 0 9.44e-06 3.3 9.479e-06 3.3 9.48e-06 0 9.519e-06 0 9.52e-06 3.3 9.559e-06 3.3 9.56e-06 0 9.579e-06 0 9.58e-06 3.3 9.599e-06 3.3 9.6e-06 0 9.639e-06 0 9.64e-06 3.3 9.659e-06 3.3 9.66e-06 0 9.679e-06 0 9.68e-06 3.3 9.699e-06 3.3 9.7e-06 0 9.719e-06 0 9.72e-06 3.3 9.739e-06 3.3 9.74e-06 0 9.779e-06 0 9.78e-06 3.3 9.799e-06 3.3 9.8e-06 0 9.839e-06 0 9.84e-06 3.3 9.859e-06 3.3 9.86e-06 0 9.899e-06 0 9.9e-06 3.3 9.919e-06 3.3 9.92e-06 0 9.939e-06 0 9.94e-06 3.3 9.979e-06 3.3 9.98e-06 0 9.999e-06 0 1e-05 3.3 1.0039e-05 3.3 1.004e-05 0 1.0079e-05 0 1.008e-05 3.3 1.0179e-05 3.3 1.018e-05 0 1.0199e-05 0 1.02e-05 3.3 1.0219e-05 3.3 1.022e-05 0 1.0459e-05 0 1.046e-05 3.3 1.0479e-05 3.3 1.048e-05 0 1.0499e-05 0 1.05e-05 3.3 1.0599e-05 3.3 1.06e-05 0 1.0619e-05 0 1.062e-05 3.3 1.0639e-05 3.3 1.064e-05 0 1.0679e-05 0 1.068e-05 3.3 1.0699e-05 3.3 1.07e-05 0 1.0719e-05 0 1.072e-05 3.3 1.0739e-05 3.3 1.074e-05 0 1.0879e-05 0 1.088e-05 3.3 1.0919e-05 3.3 1.092e-05 0 1.0939e-05 0 1.094e-05 3.3 1.0959e-05 3.3 1.096e-05 0 1.0979e-05 0 1.098e-05 3.3 1.0999e-05 3.3 1.1e-05 0 1.1039e-05 0 1.104e-05 3.3 1.1059e-05 3.3 1.106e-05 0 1.1079e-05 0 1.108e-05 3.3 1.1139e-05 3.3 1.114e-05 0 1.1159e-05 0 1.116e-05 3.3 1.1179e-05 3.3 1.118e-05 0 1.1199e-05 0 1.12e-05 3.3 1.1219e-05 3.3 1.122e-05 0 1.1259e-05 0 1.126e-05 3.3 1.1319e-05 3.3 1.132e-05 0 1.1399e-05 0 1.14e-05 3.3 1.1439e-05 3.3 1.144e-05 0 1.1459e-05 0 1.146e-05 3.3 1.1479e-05 3.3 1.148e-05 0 1.1499e-05 0 1.15e-05 3.3 1.1559e-05 3.3 1.156e-05 0 1.1619e-05 0 1.162e-05 3.3 1.1659e-05 3.3 1.166e-05 0 1.1719e-05 0 1.172e-05 3.3 1.1739e-05 3.3 1.174e-05 0 1.1759e-05 0 1.176e-05 3.3 1.1779e-05 3.3 1.178e-05 0 1.1819e-05 0 1.182e-05 3.3 1.1859e-05 3.3 1.186e-05 0 1.1899e-05 0 1.19e-05 3.3 1.1919e-05 3.3 1.192e-05 0 1.1939e-05 0 1.194e-05 3.3 1.1959e-05 3.3 1.196e-05 0 1.1979e-05 0 1.198e-05 3.3 1.2019e-05 3.3 1.202e-05 0 1.2059e-05 0 1.206e-05 3.3 1.2099e-05 3.3 1.21e-05 0 1.2119e-05 0 1.212e-05 3.3 1.2139e-05 3.3 1.214e-05 0 1.2159e-05 0 1.216e-05 3.3 1.2179e-05 3.3 1.218e-05 0 1.2199e-05 0 1.22e-05 3.3 1.2219e-05 3.3 1.222e-05 0 1.2259e-05 0 1.226e-05 3.3 1.2279e-05 3.3 1.228e-05 0 1.2319e-05 0 1.232e-05 3.3 1.2339e-05 3.3 1.234e-05 0 1.2379e-05 0 1.238e-05 3.3 1.2399e-05 3.3 1.24e-05 0 1.2419e-05 0 1.242e-05 3.3 1.2439e-05 3.3 1.244e-05 0 1.2479e-05 0 1.248e-05 3.3 1.2659e-05 3.3 1.266e-05 0 1.2679e-05 0 1.268e-05 3.3 1.2699e-05 3.3 1.27e-05 0 1.2719e-05 0 1.272e-05 3.3 1.2759e-05 3.3 1.276e-05 0 1.2799e-05 0 1.28e-05 3.3 1.2839e-05 3.3 1.284e-05 0 1.2879e-05 0 1.288e-05 3.3 1.2899e-05 3.3 1.29e-05 0 1.2939e-05 0 1.294e-05 3.3 1.2959e-05 3.3 1.296e-05 0 1.2979e-05 0 1.298e-05 3.3 1.2999e-05 3.3 1.3e-05 0 1.3019e-05 0 1.302e-05 3.3 1.3139e-05 3.3 1.314e-05 0 1.3159e-05 0 1.316e-05 3.3 1.3179e-05 3.3 1.318e-05 0 1.3199e-05 0 1.32e-05 3.3 1.3219e-05 3.3 1.322e-05 0 1.3239e-05 0 1.324e-05 3.3 1.3259e-05 3.3 1.326e-05 0 1.3379e-05 0 1.338e-05 3.3 1.3399e-05 3.3 1.34e-05 0 1.3419e-05 0 1.342e-05 3.3 1.3459e-05 3.3 1.346e-05 0 1.3499e-05 0 1.35e-05 3.3 1.3539e-05 3.3 1.354e-05 0 1.3599e-05 0 1.36e-05 3.3 1.3659e-05 3.3 1.366e-05 0 1.3679e-05 0 1.368e-05 3.3 1.3699e-05 3.3 1.37e-05 0 1.3839e-05 0 1.384e-05 3.3 1.3899e-05 3.3 1.39e-05 0 1.3939e-05 0 1.394e-05 3.3 1.3959e-05 3.3 1.396e-05 0 1.3979e-05 0 1.398e-05 3.3 1.4079e-05 3.3 1.408e-05 0 1.4099e-05 0 1.41e-05 3.3 1.4139e-05 3.3 1.414e-05 0 1.4159e-05 0 1.416e-05 3.3 1.4179e-05 3.3 1.418e-05 0 1.4199e-05 0 1.42e-05 3.3 1.4219e-05 3.3 1.422e-05 0 1.4239e-05 0 1.424e-05 3.3 1.4259e-05 3.3 1.426e-05 0 1.4299e-05 0 1.43e-05 3.3 1.4319e-05 3.3 1.432e-05 0 1.4359e-05 0 1.436e-05 3.3 1.4399e-05 3.3 1.44e-05 0 1.4419e-05 0 1.442e-05 3.3 1.4439e-05 3.3 1.444e-05 0 1.4459e-05 0 1.446e-05 3.3 1.4479e-05 3.3 1.448e-05 0 1.4519e-05 0 1.452e-05 3.3 1.4539e-05 3.3 1.454e-05 0 1.4599e-05 0 1.46e-05 3.3 1.4639e-05 3.3 1.464e-05 0 1.4679e-05 0 1.468e-05 3.3 1.4739e-05 3.3 1.474e-05 0 1.4939e-05 0 1.494e-05 3.3 1.4959e-05 3.3 1.496e-05 0 1.5019e-05 0 1.502e-05 3.3 1.5099e-05 3.3 1.51e-05 0 1.5119e-05 0 1.512e-05 3.3 1.5159e-05 3.3 1.516e-05 0 1.5199e-05 0 1.52e-05 3.3 1.5219e-05 3.3 1.522e-05 0 1.5239e-05 0 1.524e-05 3.3 1.5299e-05 3.3 1.53e-05 0 1.5319e-05 0 1.532e-05 3.3 1.5339e-05 3.3 1.534e-05 0 1.5359e-05 0 1.536e-05 3.3 1.5399e-05 3.3 1.54e-05 0 1.5419e-05 0 1.542e-05 3.3 1.5439e-05 3.3 1.544e-05 0 1.5459e-05 0 1.546e-05 3.3 1.5479e-05 3.3 1.548e-05 0 1.5499e-05 0 1.55e-05 3.3 1.5539e-05 3.3 1.554e-05 0 1.5579e-05 0 1.558e-05 3.3 1.5599e-05 3.3 1.56e-05 0 1.5619e-05 0 1.562e-05 3.3 1.5659e-05 3.3 1.566e-05 0 1.5679e-05 0 1.568e-05 3.3 1.5719e-05 3.3 1.572e-05 0 1.5739e-05 0 1.574e-05 3.3 1.5779e-05 3.3 1.578e-05 0 1.5819e-05 0 1.582e-05 3.3 1.5859e-05 3.3 1.586e-05 0 1.5879e-05 0 1.588e-05 3.3 1.5899e-05 3.3 1.59e-05 0 1.5939e-05 0 1.594e-05 3.3 1.5979e-05 3.3 1.598e-05 0 1.6e-05 0)
V5 B_6_2[4] GND PWL(0 3.3 2.19e-07 3.3 2.2e-07 0 2.39e-07 0 2.4e-07 3.3 2.59e-07 3.3 2.6e-07 0 3.39e-07 0 3.4e-07 3.3 3.99e-07 3.3 4e-07 0 4.39e-07 0 4.4e-07 3.3 4.79e-07 3.3 4.8e-07 0 4.99e-07 0 5e-07 3.3 5.19e-07 3.3 5.2e-07 0 5.39e-07 0 5.4e-07 3.3 6.19e-07 3.3 6.2e-07 0 6.79e-07 0 6.8e-07 3.3 7.19e-07 3.3 7.2e-07 0 7.79e-07 0 7.8e-07 3.3 8.19e-07 3.3 8.2e-07 0 8.99e-07 0 9e-07 3.3 9.39e-07 3.3 9.4e-07 0 9.79e-07 0 9.8e-07 3.3 1.179e-06 3.3 1.18e-06 0 1.219e-06 0 1.22e-06 3.3 1.259e-06 3.3 1.26e-06 0 1.339e-06 0 1.34e-06 3.3 1.419e-06 3.3 1.42e-06 0 1.459e-06 0 1.46e-06 3.3 1.499e-06 3.3 1.5e-06 0 1.539e-06 0 1.54e-06 3.3 1.599e-06 3.3 1.6e-06 0 1.639e-06 0 1.64e-06 3.3 1.679e-06 3.3 1.68e-06 0 1.719e-06 0 1.72e-06 3.3 1.819e-06 3.3 1.82e-06 0 1.879e-06 0 1.88e-06 3.3 1.899e-06 3.3 1.9e-06 0 1.979e-06 0 1.98e-06 3.3 2.039e-06 3.3 2.04e-06 0 2.099e-06 0 2.1e-06 3.3 2.159e-06 3.3 2.16e-06 0 2.179e-06 0 2.18e-06 3.3 2.239e-06 3.3 2.24e-06 0 2.439e-06 0 2.44e-06 3.3 2.459e-06 3.3 2.46e-06 0 2.519e-06 0 2.52e-06 3.3 2.619e-06 3.3 2.62e-06 0 2.679e-06 0 2.68e-06 3.3 2.719e-06 3.3 2.72e-06 0 2.739e-06 0 2.74e-06 3.3 2.759e-06 3.3 2.76e-06 0 2.779e-06 0 2.78e-06 3.3 2.799e-06 3.3 2.8e-06 0 2.859e-06 0 2.86e-06 3.3 2.879e-06 3.3 2.88e-06 0 2.919e-06 0 2.92e-06 3.3 2.959e-06 3.3 2.96e-06 0 2.999e-06 0 3e-06 3.3 3.059e-06 3.3 3.06e-06 0 3.079e-06 0 3.08e-06 3.3 3.179e-06 3.3 3.18e-06 0 3.199e-06 0 3.2e-06 3.3 3.259e-06 3.3 3.26e-06 0 3.399e-06 0 3.4e-06 3.3 3.419e-06 3.3 3.42e-06 0 3.459e-06 0 3.46e-06 3.3 3.479e-06 3.3 3.48e-06 0 3.499e-06 0 3.5e-06 3.3 3.619e-06 3.3 3.62e-06 0 3.699e-06 0 3.7e-06 3.3 3.739e-06 3.3 3.74e-06 0 3.759e-06 0 3.76e-06 3.3 3.779e-06 3.3 3.78e-06 0 3.819e-06 0 3.82e-06 3.3 3.839e-06 3.3 3.84e-06 0 3.859e-06 0 3.86e-06 3.3 3.919e-06 3.3 3.92e-06 0 3.959e-06 0 3.96e-06 3.3 4.039e-06 3.3 4.04e-06 0 4.059e-06 0 4.06e-06 3.3 4.099e-06 3.3 4.1e-06 0 4.119e-06 0 4.12e-06 3.3 4.139e-06 3.3 4.14e-06 0 4.199e-06 0 4.2e-06 3.3 4.259e-06 3.3 4.26e-06 0 4.319e-06 0 4.32e-06 3.3 4.339e-06 3.3 4.34e-06 0 4.379e-06 0 4.38e-06 3.3 4.399e-06 3.3 4.4e-06 0 4.419e-06 0 4.42e-06 3.3 4.459e-06 3.3 4.46e-06 0 4.479e-06 0 4.48e-06 3.3 4.659e-06 3.3 4.66e-06 0 4.679e-06 0 4.68e-06 3.3 4.699e-06 3.3 4.7e-06 0 4.739e-06 0 4.74e-06 3.3 4.759e-06 3.3 4.76e-06 0 4.799e-06 0 4.8e-06 3.3 4.839e-06 3.3 4.84e-06 0 4.899e-06 0 4.9e-06 3.3 4.959e-06 3.3 4.96e-06 0 4.979e-06 0 4.98e-06 3.3 5.079e-06 3.3 5.08e-06 0 5.099e-06 0 5.1e-06 3.3 5.119e-06 3.3 5.12e-06 0 5.159e-06 0 5.16e-06 3.3 5.199e-06 3.3 5.2e-06 0 5.239e-06 0 5.24e-06 3.3 5.299e-06 3.3 5.3e-06 0 5.359e-06 0 5.36e-06 3.3 5.419e-06 3.3 5.42e-06 0 5.439e-06 0 5.44e-06 3.3 5.459e-06 3.3 5.46e-06 0 5.539e-06 0 5.54e-06 3.3 5.639e-06 3.3 5.64e-06 0 5.699e-06 0 5.7e-06 3.3 5.719e-06 3.3 5.72e-06 0 5.899e-06 0 5.9e-06 3.3 5.979e-06 3.3 5.98e-06 0 5.999e-06 0 6e-06 3.3 6.059e-06 3.3 6.06e-06 0 6.099e-06 0 6.1e-06 3.3 6.159e-06 3.3 6.16e-06 0 6.199e-06 0 6.2e-06 3.3 6.239e-06 3.3 6.24e-06 0 6.259e-06 0 6.26e-06 3.3 6.279e-06 3.3 6.28e-06 0 6.339e-06 0 6.34e-06 3.3 6.379e-06 3.3 6.38e-06 0 6.439e-06 0 6.44e-06 3.3 6.479e-06 3.3 6.48e-06 0 6.539e-06 0 6.54e-06 3.3 6.619e-06 3.3 6.62e-06 0 6.659e-06 0 6.66e-06 3.3 6.699e-06 3.3 6.7e-06 0 6.899e-06 0 6.9e-06 3.3 6.939e-06 3.3 6.94e-06 0 6.979e-06 0 6.98e-06 3.3 7.039e-06 3.3 7.04e-06 0 7.119e-06 0 7.12e-06 3.3 7.199e-06 3.3 7.2e-06 0 7.219e-06 0 7.22e-06 3.3 7.259e-06 3.3 7.26e-06 0 7.339e-06 0 7.34e-06 3.3 7.359e-06 3.3 7.36e-06 0 7.399e-06 0 7.4e-06 3.3 7.439e-06 3.3 7.44e-06 0 7.479e-06 0 7.48e-06 3.3 7.619e-06 3.3 7.62e-06 0 7.639e-06 0 7.64e-06 3.3 7.659e-06 3.3 7.66e-06 0 7.739e-06 0 7.74e-06 3.3 7.819e-06 3.3 7.82e-06 0 7.899e-06 0 7.9e-06 3.3 7.919e-06 3.3 7.92e-06 0 7.939e-06 0 7.94e-06 3.3 7.959e-06 3.3 7.96e-06 0 7.979e-06 0 7.98e-06 3.3 8.219e-06 3.3 8.22e-06 0 8.239e-06 0 8.24e-06 3.3 8.259e-06 3.3 8.26e-06 0 8.339e-06 0 8.34e-06 3.3 8.399e-06 3.3 8.4e-06 0 8.439e-06 0 8.44e-06 3.3 8.479e-06 3.3 8.48e-06 0 8.499e-06 0 8.5e-06 3.3 8.519e-06 3.3 8.52e-06 0 8.539e-06 0 8.54e-06 3.3 8.619e-06 3.3 8.62e-06 0 8.679e-06 0 8.68e-06 3.3 8.719e-06 3.3 8.72e-06 0 8.779e-06 0 8.78e-06 3.3 8.819e-06 3.3 8.82e-06 0 8.899e-06 0 8.9e-06 3.3 8.939e-06 3.3 8.94e-06 0 8.979e-06 0 8.98e-06 3.3 9.179e-06 3.3 9.18e-06 0 9.219e-06 0 9.22e-06 3.3 9.259e-06 3.3 9.26e-06 0 9.339e-06 0 9.34e-06 3.3 9.419e-06 3.3 9.42e-06 0 9.459e-06 0 9.46e-06 3.3 9.499e-06 3.3 9.5e-06 0 9.539e-06 0 9.54e-06 3.3 9.599e-06 3.3 9.6e-06 0 9.639e-06 0 9.64e-06 3.3 9.679e-06 3.3 9.68e-06 0 9.719e-06 0 9.72e-06 3.3 9.819e-06 3.3 9.82e-06 0 9.879e-06 0 9.88e-06 3.3 9.899e-06 3.3 9.9e-06 0 9.979e-06 0 9.98e-06 3.3 1.0039e-05 3.3 1.004e-05 0 1.0099e-05 0 1.01e-05 3.3 1.0159e-05 3.3 1.016e-05 0 1.0179e-05 0 1.018e-05 3.3 1.0239e-05 3.3 1.024e-05 0 1.0439e-05 0 1.044e-05 3.3 1.0459e-05 3.3 1.046e-05 0 1.0519e-05 0 1.052e-05 3.3 1.0619e-05 3.3 1.062e-05 0 1.0679e-05 0 1.068e-05 3.3 1.0719e-05 3.3 1.072e-05 0 1.0739e-05 0 1.074e-05 3.3 1.0759e-05 3.3 1.076e-05 0 1.0779e-05 0 1.078e-05 3.3 1.0799e-05 3.3 1.08e-05 0 1.0859e-05 0 1.086e-05 3.3 1.0879e-05 3.3 1.088e-05 0 1.0919e-05 0 1.092e-05 3.3 1.0959e-05 3.3 1.096e-05 0 1.0999e-05 0 1.1e-05 3.3 1.1059e-05 3.3 1.106e-05 0 1.1079e-05 0 1.108e-05 3.3 1.1179e-05 3.3 1.118e-05 0 1.1199e-05 0 1.12e-05 3.3 1.1259e-05 3.3 1.126e-05 0 1.1399e-05 0 1.14e-05 3.3 1.1419e-05 3.3 1.142e-05 0 1.1459e-05 0 1.146e-05 3.3 1.1479e-05 3.3 1.148e-05 0 1.1499e-05 0 1.15e-05 3.3 1.1619e-05 3.3 1.162e-05 0 1.1699e-05 0 1.17e-05 3.3 1.1739e-05 3.3 1.174e-05 0 1.1759e-05 0 1.176e-05 3.3 1.1779e-05 3.3 1.178e-05 0 1.1819e-05 0 1.182e-05 3.3 1.1839e-05 3.3 1.184e-05 0 1.1859e-05 0 1.186e-05 3.3 1.1919e-05 3.3 1.192e-05 0 1.1959e-05 0 1.196e-05 3.3 1.2039e-05 3.3 1.204e-05 0 1.2059e-05 0 1.206e-05 3.3 1.2099e-05 3.3 1.21e-05 0 1.2119e-05 0 1.212e-05 3.3 1.2139e-05 3.3 1.214e-05 0 1.2199e-05 0 1.22e-05 3.3 1.2259e-05 3.3 1.226e-05 0 1.2319e-05 0 1.232e-05 3.3 1.2339e-05 3.3 1.234e-05 0 1.2379e-05 0 1.238e-05 3.3 1.2399e-05 3.3 1.24e-05 0 1.2419e-05 0 1.242e-05 3.3 1.2459e-05 3.3 1.246e-05 0 1.2479e-05 0 1.248e-05 3.3 1.2659e-05 3.3 1.266e-05 0 1.2679e-05 0 1.268e-05 3.3 1.2699e-05 3.3 1.27e-05 0 1.2739e-05 0 1.274e-05 3.3 1.2759e-05 3.3 1.276e-05 0 1.2799e-05 0 1.28e-05 3.3 1.2839e-05 3.3 1.284e-05 0 1.2899e-05 0 1.29e-05 3.3 1.2959e-05 3.3 1.296e-05 0 1.2979e-05 0 1.298e-05 3.3 1.3079e-05 3.3 1.308e-05 0 1.3099e-05 0 1.31e-05 3.3 1.3119e-05 3.3 1.312e-05 0 1.3159e-05 0 1.316e-05 3.3 1.3199e-05 3.3 1.32e-05 0 1.3239e-05 0 1.324e-05 3.3 1.3299e-05 3.3 1.33e-05 0 1.3359e-05 0 1.336e-05 3.3 1.3419e-05 3.3 1.342e-05 0 1.3439e-05 0 1.344e-05 3.3 1.3459e-05 3.3 1.346e-05 0 1.3539e-05 0 1.354e-05 3.3 1.3639e-05 3.3 1.364e-05 0 1.3699e-05 0 1.37e-05 3.3 1.3719e-05 3.3 1.372e-05 0 1.3899e-05 0 1.39e-05 3.3 1.3979e-05 3.3 1.398e-05 0 1.3999e-05 0 1.4e-05 3.3 1.4059e-05 3.3 1.406e-05 0 1.4099e-05 0 1.41e-05 3.3 1.4159e-05 3.3 1.416e-05 0 1.4199e-05 0 1.42e-05 3.3 1.4239e-05 3.3 1.424e-05 0 1.4259e-05 0 1.426e-05 3.3 1.4279e-05 3.3 1.428e-05 0 1.4339e-05 0 1.434e-05 3.3 1.4379e-05 3.3 1.438e-05 0 1.4439e-05 0 1.444e-05 3.3 1.4479e-05 3.3 1.448e-05 0 1.4539e-05 0 1.454e-05 3.3 1.4619e-05 3.3 1.462e-05 0 1.4659e-05 0 1.466e-05 3.3 1.4699e-05 3.3 1.47e-05 0 1.4899e-05 0 1.49e-05 3.3 1.4939e-05 3.3 1.494e-05 0 1.4979e-05 0 1.498e-05 3.3 1.5039e-05 3.3 1.504e-05 0 1.5119e-05 0 1.512e-05 3.3 1.5199e-05 3.3 1.52e-05 0 1.5219e-05 0 1.522e-05 3.3 1.5259e-05 3.3 1.526e-05 0 1.5339e-05 0 1.534e-05 3.3 1.5359e-05 3.3 1.536e-05 0 1.5399e-05 0 1.54e-05 3.3 1.5439e-05 3.3 1.544e-05 0 1.5479e-05 0 1.548e-05 3.3 1.5619e-05 3.3 1.562e-05 0 1.5639e-05 0 1.564e-05 3.3 1.5659e-05 3.3 1.566e-05 0 1.5739e-05 0 1.574e-05 3.3 1.5819e-05 3.3 1.582e-05 0 1.5899e-05 0 1.59e-05 3.3 1.5919e-05 3.3 1.592e-05 0 1.5939e-05 0 1.594e-05 3.3 1.5959e-05 3.3 1.596e-05 0 1.5979e-05 0 1.598e-05 3.3 1.6e-05 3.3)
V6 B_6_2[5] GND PWL(0 3.3 1.79e-07 3.3 1.8e-07 0 2.19e-07 0 2.2e-07 3.3 2.59e-07 3.3 2.6e-07 0 3.19e-07 0 3.2e-07 3.3 3.99e-07 3.3 4e-07 0 4.79e-07 0 4.8e-07 3.3 4.99e-07 3.3 5e-07 0 5.39e-07 0 5.4e-07 3.3 5.99e-07 3.3 6e-07 0 6.19e-07 0 6.2e-07 3.3 6.79e-07 3.3 6.8e-07 0 7.79e-07 0 7.8e-07 3.3 8.19e-07 3.3 8.2e-07 0 8.79e-07 0 8.8e-07 3.3 8.99e-07 3.3 9e-07 0 9.59e-07 0 9.6e-07 3.3 1.159e-06 3.3 1.16e-06 0 1.179e-06 0 1.18e-06 3.3 1.239e-06 3.3 1.24e-06 0 1.419e-06 0 1.42e-06 3.3 1.459e-06 3.3 1.46e-06 0 1.519e-06 0 1.52e-06 3.3 1.579e-06 3.3 1.58e-06 0 1.599e-06 0 1.6e-06 3.3 1.639e-06 3.3 1.64e-06 0 1.719e-06 0 1.72e-06 3.3 1.799e-06 3.3 1.8e-06 0 1.859e-06 0 1.86e-06 3.3 1.879e-06 3.3 1.88e-06 0 2.039e-06 0 2.04e-06 3.3 2.139e-06 3.3 2.14e-06 0 2.159e-06 0 2.16e-06 3.3 2.219e-06 3.3 2.22e-06 0 2.419e-06 0 2.42e-06 3.3 2.439e-06 3.3 2.44e-06 0 2.499e-06 0 2.5e-06 3.3 2.559e-06 3.3 2.56e-06 0 2.679e-06 0 2.68e-06 3.3 2.759e-06 3.3 2.76e-06 0 2.839e-06 0 2.84e-06 3.3 2.859e-06 3.3 2.86e-06 0 2.959e-06 0 2.96e-06 3.3 3.119e-06 3.3 3.12e-06 0 3.139e-06 0 3.14e-06 3.3 3.179e-06 3.3 3.18e-06 0 3.459e-06 0 3.46e-06 3.3 3.739e-06 3.3 3.74e-06 0 3.919e-06 0 3.92e-06 3.3 4.139e-06 3.3 4.14e-06 0 4.199e-06 0 4.2e-06 3.3 4.319e-06 3.3 4.32e-06 0 4.419e-06 0 4.42e-06 3.3 4.699e-06 3.3 4.7e-06 0 4.839e-06 0 4.84e-06 3.3 4.959e-06 3.3 4.96e-06 0 4.979e-06 0 4.98e-06 3.3 5.019e-06 3.3 5.02e-06 0 5.039e-06 0 5.04e-06 3.3 5.119e-06 3.3 5.12e-06 0 5.159e-06 0 5.16e-06 3.3 5.239e-06 3.3 5.24e-06 0 5.299e-06 0 5.3e-06 3.3 5.319e-06 3.3 5.32e-06 0 5.379e-06 0 5.38e-06 3.3 5.439e-06 3.3 5.44e-06 0 5.459e-06 0 5.46e-06 3.3 5.659e-06 3.3 5.66e-06 0 5.719e-06 0 5.72e-06 3.3 5.739e-06 3.3 5.74e-06 0 5.939e-06 0 5.94e-06 3.3 5.999e-06 3.3 6e-06 0 6.019e-06 0 6.02e-06 3.3 6.079e-06 3.3 6.08e-06 0 6.099e-06 0 6.1e-06 3.3 6.199e-06 3.3 6.2e-06 0 6.279e-06 0 6.28e-06 3.3 6.299e-06 3.3 6.3e-06 0 6.359e-06 0 6.36e-06 3.3 6.479e-06 3.3 6.48e-06 0 6.579e-06 0 6.58e-06 3.3 6.639e-06 3.3 6.64e-06 0 6.699e-06 0 6.7e-06 3.3 6.719e-06 3.3 6.72e-06 0 6.919e-06 0 6.92e-06 3.3 6.979e-06 3.3 6.98e-06 0 6.999e-06 0 7e-06 3.3 7.119e-06 3.3 7.12e-06 0 7.259e-06 0 7.26e-06 3.3 7.279e-06 3.3 7.28e-06 0 7.339e-06 0 7.34e-06 3.3 7.439e-06 3.3 7.44e-06 0 7.559e-06 0 7.56e-06 3.3 7.619e-06 3.3 7.62e-06 0 7.659e-06 0 7.66e-06 3.3 7.739e-06 3.3 7.74e-06 0 7.899e-06 0 7.9e-06 3.3 7.939e-06 3.3 7.94e-06 0 7.979e-06 0 7.98e-06 3.3 8.179e-06 3.3 8.18e-06 0 8.219e-06 0 8.22e-06 3.3 8.259e-06 3.3 8.26e-06 0 8.319e-06 0 8.32e-06 3.3 8.399e-06 3.3 8.4e-06 0 8.479e-06 0 8.48e-06 3.3 8.499e-06 3.3 8.5e-06 0 8.539e-06 0 8.54e-06 3.3 8.599e-06 3.3 8.6e-06 0 8.619e-06 0 8.62e-06 3.3 8.679e-06 3.3 8.68e-06 0 8.779e-06 0 8.78e-06 3.3 8.819e-06 3.3 8.82e-06 0 8.879e-06 0 8.88e-06 3.3 8.899e-06 3.3 8.9e-06 0 8.959e-06 0 8.96e-06 3.3 9.159e-06 3.3 9.16e-06 0 9.179e-06 0 9.18e-06 3.3 9.239e-06 3.3 9.24e-06 0 9.419e-06 0 9.42e-06 3.3 9.459e-06 3.3 9.46e-06 0 9.519e-06 0 9.52e-06 3.3 9.579e-06 3.3 9.58e-06 0 9.599e-06 0 9.6e-06 3.3 9.639e-06 3.3 9.64e-06 0 9.719e-06 0 9.72e-06 3.3 9.799e-06 3.3 9.8e-06 0 9.859e-06 0 9.86e-06 3.3 9.879e-06 3.3 9.88e-06 0 1.0039e-05 0 1.004e-05 3.3 1.0139e-05 3.3 1.014e-05 0 1.0159e-05 0 1.016e-05 3.3 1.0219e-05 3.3 1.022e-05 0 1.0419e-05 0 1.042e-05 3.3 1.0439e-05 3.3 1.044e-05 0 1.0499e-05 0 1.05e-05 3.3 1.0559e-05 3.3 1.056e-05 0 1.0679e-05 0 1.068e-05 3.3 1.0759e-05 3.3 1.076e-05 0 1.0839e-05 0 1.084e-05 3.3 1.0859e-05 3.3 1.086e-05 0 1.0959e-05 0 1.096e-05 3.3 1.1119e-05 3.3 1.112e-05 0 1.1139e-05 0 1.114e-05 3.3 1.1179e-05 3.3 1.118e-05 0 1.1459e-05 0 1.146e-05 3.3 1.1739e-05 3.3 1.174e-05 0 1.1919e-05 0 1.192e-05 3.3 1.2139e-05 3.3 1.214e-05 0 1.2199e-05 0 1.22e-05 3.3 1.2319e-05 3.3 1.232e-05 0 1.2419e-05 0 1.242e-05 3.3 1.2699e-05 3.3 1.27e-05 0 1.2839e-05 0 1.284e-05 3.3 1.2959e-05 3.3 1.296e-05 0 1.2979e-05 0 1.298e-05 3.3 1.3019e-05 3.3 1.302e-05 0 1.3039e-05 0 1.304e-05 3.3 1.3119e-05 3.3 1.312e-05 0 1.3159e-05 0 1.316e-05 3.3 1.3239e-05 3.3 1.324e-05 0 1.3299e-05 0 1.33e-05 3.3 1.3319e-05 3.3 1.332e-05 0 1.3379e-05 0 1.338e-05 3.3 1.3439e-05 3.3 1.344e-05 0 1.3459e-05 0 1.346e-05 3.3 1.3659e-05 3.3 1.366e-05 0 1.3719e-05 0 1.372e-05 3.3 1.3739e-05 3.3 1.374e-05 0 1.3939e-05 0 1.394e-05 3.3 1.3999e-05 3.3 1.4e-05 0 1.4019e-05 0 1.402e-05 3.3 1.4079e-05 3.3 1.408e-05 0 1.4099e-05 0 1.41e-05 3.3 1.4199e-05 3.3 1.42e-05 0 1.4279e-05 0 1.428e-05 3.3 1.4299e-05 3.3 1.43e-05 0 1.4359e-05 0 1.436e-05 3.3 1.4479e-05 3.3 1.448e-05 0 1.4579e-05 0 1.458e-05 3.3 1.4639e-05 3.3 1.464e-05 0 1.4699e-05 0 1.47e-05 3.3 1.4719e-05 3.3 1.472e-05 0 1.4919e-05 0 1.492e-05 3.3 1.4979e-05 3.3 1.498e-05 0 1.4999e-05 0 1.5e-05 3.3 1.5119e-05 3.3 1.512e-05 0 1.5259e-05 0 1.526e-05 3.3 1.5279e-05 3.3 1.528e-05 0 1.5339e-05 0 1.534e-05 3.3 1.5439e-05 3.3 1.544e-05 0 1.5559e-05 0 1.556e-05 3.3 1.5619e-05 3.3 1.562e-05 0 1.5659e-05 0 1.566e-05 3.3 1.5739e-05 3.3 1.574e-05 0 1.5899e-05 0 1.59e-05 3.3 1.5939e-05 3.3 1.594e-05 0 1.5979e-05 0 1.598e-05 3.3 1.6e-05 3.3)
V7 T_6_2[0] GND PWL(0 3.3 2.39e-07 3.3 2.4e-07 0 3.99e-07 0 4e-07 3.3 7.79e-07 3.3 7.8e-07 0 8.99e-07 0 9e-07 3.3 1.219e-06 3.3 1.22e-06 0 1.459e-06 0 1.46e-06 3.3 1.779e-06 3.3 1.78e-06 0 1.879e-06 0 1.88e-06 3.3 2.199e-06 3.3 2.2e-06 0 2.439e-06 0 2.44e-06 3.3 2.779e-06 3.3 2.78e-06 0 2.859e-06 0 2.86e-06 3.3 3.199e-06 3.3 3.2e-06 0 3.419e-06 0 3.42e-06 3.3 3.759e-06 3.3 3.76e-06 0 3.839e-06 0 3.84e-06 3.3 4.199e-06 3.3 4.2e-06 0 4.399e-06 0 4.4e-06 3.3 4.739e-06 3.3 4.74e-06 0 4.959e-06 0 4.96e-06 3.3 5.299e-06 3.3 5.3e-06 0 5.399e-06 0 5.4e-06 3.3 5.719e-06 3.3 5.72e-06 0 5.959e-06 0 5.96e-06 3.3 6.279e-06 3.3 6.28e-06 0 6.379e-06 0 6.38e-06 3.3 6.699e-06 3.3 6.7e-06 0 6.939e-06 0 6.94e-06 3.3 7.259e-06 3.3 7.26e-06 0 7.359e-06 0 7.36e-06 3.3 7.679e-06 3.3 7.68e-06 0 7.919e-06 0 7.92e-06 3.3 8.239e-06 3.3 8.24e-06 0 8.399e-06 0 8.4e-06 3.3 8.779e-06 3.3 8.78e-06 0 8.899e-06 0 8.9e-06 3.3 9.219e-06 3.3 9.22e-06 0 9.459e-06 0 9.46e-06 3.3 9.779e-06 3.3 9.78e-06 0 9.879e-06 0 9.88e-06 3.3 1.0199e-05 3.3 1.02e-05 0 1.0439e-05 0 1.044e-05 3.3 1.0779e-05 3.3 1.078e-05 0 1.0859e-05 0 1.086e-05 3.3 1.1199e-05 3.3 1.12e-05 0 1.1419e-05 0 1.142e-05 3.3 1.1759e-05 3.3 1.176e-05 0 1.1839e-05 0 1.184e-05 3.3 1.2199e-05 3.3 1.22e-05 0 1.2399e-05 0 1.24e-05 3.3 1.2739e-05 3.3 1.274e-05 0 1.2959e-05 0 1.296e-05 3.3 1.3299e-05 3.3 1.33e-05 0 1.3399e-05 0 1.34e-05 3.3 1.3719e-05 3.3 1.372e-05 0 1.3959e-05 0 1.396e-05 3.3 1.4279e-05 3.3 1.428e-05 0 1.4379e-05 0 1.438e-05 3.3 1.4699e-05 3.3 1.47e-05 0 1.4939e-05 0 1.494e-05 3.3 1.5259e-05 3.3 1.526e-05 0 1.5359e-05 0 1.536e-05 3.3 1.5679e-05 3.3 1.568e-05 0 1.5919e-05 0 1.592e-05 3.3 1.6e-05 3.3)
V8 T_6_2[1] GND PWL(0 3.3 2.19e-07 3.3 2.2e-07 0 4.99e-07 0 5e-07 3.3 6.39e-07 3.3 6.4e-07 0 9.19e-07 0 9.2e-07 3.3 1.199e-06 3.3 1.2e-06 0 1.479e-06 0 1.48e-06 3.3 1.719e-06 3.3 1.72e-06 0 1.899e-06 0 1.9e-06 3.3 2.179e-06 3.3 2.18e-06 0 2.459e-06 0 2.46e-06 3.3 2.739e-06 3.3 2.74e-06 0 2.879e-06 0 2.88e-06 3.3 3.159e-06 3.3 3.16e-06 0 3.439e-06 0 3.44e-06 3.3 3.719e-06 3.3 3.72e-06 0 4.019e-06 0 4.02e-06 3.3 4.159e-06 3.3 4.16e-06 0 4.439e-06 0 4.44e-06 3.3 4.719e-06 3.3 4.72e-06 0 4.999e-06 0 5e-06 3.3 5.159e-06 3.3 5.16e-06 0 5.419e-06 0 5.42e-06 3.3 5.699e-06 3.3 5.7e-06 0 5.979e-06 0 5.98e-06 3.3 6.259e-06 3.3 6.26e-06 0 6.399e-06 0 6.4e-06 3.3 6.679e-06 3.3 6.68e-06 0 6.959e-06 0 6.96e-06 3.3 7.239e-06 3.3 7.24e-06 0 7.439e-06 0 7.44e-06 3.3 7.659e-06 3.3 7.66e-06 0 7.939e-06 0 7.94e-06 3.3 8.219e-06 3.3 8.22e-06 0 8.499e-06 0 8.5e-06 3.3 8.639e-06 3.3 8.64e-06 0 8.919e-06 0 8.92e-06 3.3 9.199e-06 3.3 9.2e-06 0 9.479e-06 0 9.48e-06 3.3 9.719e-06 3.3 9.72e-06 0 9.899e-06 0 9.9e-06 3.3 1.0179e-05 3.3 1.018e-05 0 1.0459e-05 0 1.046e-05 3.3 1.0739e-05 3.3 1.074e-05 0 1.0879e-05 0 1.088e-05 3.3 1.1159e-05 3.3 1.116e-05 0 1.1439e-05 0 1.144e-05 3.3 1.1719e-05 3.3 1.172e-05 0 1.2019e-05 0 1.202e-05 3.3 1.2159e-05 3.3 1.216e-05 0 1.2439e-05 0 1.244e-05 3.3 1.2719e-05 3.3 1.272e-05 0 1.2999e-05 0 1.3e-05 3.3 1.3159e-05 3.3 1.316e-05 0 1.3419e-05 0 1.342e-05 3.3 1.3699e-05 3.3 1.37e-05 0 1.3979e-05 0 1.398e-05 3.3 1.4259e-05 3.3 1.426e-05 0 1.4399e-05 0 1.44e-05 3.3 1.4679e-05 3.3 1.468e-05 0 1.4959e-05 0 1.496e-05 3.3 1.5239e-05 3.3 1.524e-05 0 1.5439e-05 0 1.544e-05 3.3 1.5659e-05 3.3 1.566e-05 0 1.5939e-05 0 1.594e-05 3.3 1.6e-05 3.3)
V9 T_6_2[2] GND PWL(0 3.3 1.99e-07 3.3 2e-07 0 5.19e-07 0 5.2e-07 3.3 6.19e-07 3.3 6.2e-07 0 9.39e-07 0 9.4e-07 3.3 1.179e-06 3.3 1.18e-06 0 1.499e-06 0 1.5e-06 3.3 1.599e-06 3.3 1.6e-06 0 1.919e-06 0 1.92e-06 3.3 2.159e-06 3.3 2.16e-06 0 2.479e-06 0 2.48e-06 3.3 2.679e-06 3.3 2.68e-06 0 3.059e-06 0 3.06e-06 3.3 3.139e-06 3.3 3.14e-06 0 3.479e-06 0 3.48e-06 3.3 3.699e-06 3.3 3.7e-06 0 4.039e-06 0 4.04e-06 3.3 4.119e-06 3.3 4.12e-06 0 4.459e-06 0 4.46e-06 3.3 4.679e-06 3.3 4.68e-06 0 5.019e-06 0 5.02e-06 3.3 5.099e-06 3.3 5.1e-06 0 5.439e-06 0 5.44e-06 3.3 5.679e-06 3.3 5.68e-06 0 5.999e-06 0 6e-06 3.3 6.099e-06 3.3 6.1e-06 0 6.479e-06 0 6.48e-06 3.3 6.659e-06 3.3 6.66e-06 0 6.979e-06 0 6.98e-06 3.3 7.219e-06 3.3 7.22e-06 0 7.539e-06 0 7.54e-06 3.3 7.639e-06 3.3 7.64e-06 0 7.959e-06 0 7.96e-06 3.3 8.199e-06 3.3 8.2e-06 0 8.519e-06 0 8.52e-06 3.3 8.619e-06 3.3 8.62e-06 0 8.939e-06 0 8.94e-06 3.3 9.179e-06 3.3 9.18e-06 0 9.499e-06 0 9.5e-06 3.3 9.599e-06 3.3 9.6e-06 0 9.919e-06 0 9.92e-06 3.3 1.0159e-05 3.3 1.016e-05 0 1.0479e-05 0 1.048e-05 3.3 1.0679e-05 3.3 1.068e-05 0 1.1059e-05 0 1.106e-05 3.3 1.1139e-05 3.3 1.114e-05 0 1.1479e-05 0 1.148e-05 3.3 1.1699e-05 3.3 1.17e-05 0 1.2039e-05 0 1.204e-05 3.3 1.2119e-05 3.3 1.212e-05 0 1.2459e-05 0 1.246e-05 3.3 1.2679e-05 3.3 1.268e-05 0 1.3019e-05 0 1.302e-05 3.3 1.3099e-05 3.3 1.31e-05 0 1.3439e-05 0 1.344e-05 3.3 1.3679e-05 3.3 1.368e-05 0 1.3999e-05 0 1.4e-05 3.3 1.4099e-05 3.3 1.41e-05 0 1.4479e-05 0 1.448e-05 3.3 1.4659e-05 3.3 1.466e-05 0 1.4979e-05 0 1.498e-05 3.3 1.5219e-05 3.3 1.522e-05 0 1.5539e-05 0 1.554e-05 3.3 1.5639e-05 3.3 1.564e-05 0 1.5959e-05 0 1.596e-05 3.3 1.6e-05 3.3)
