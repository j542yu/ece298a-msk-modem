* Automatically generated 8-bit DAC stimuli
* Code sweep: 0 to 255
* B inputs are binary; T inputs are thermometer encoded

V1 B[0] GND PWL(0 0 9.99e-07 0 1e-06 1.8 1.999e-06 1.8 2e-06 0 2.999e-06 0 3e-06 1.8 3.999e-06 1.8 4e-06 0 4.999e-06 0 5e-06 1.8 5.999e-06 1.8 6e-06 0 6.999e-06 0 7e-06 1.8 7.999e-06 1.8 8e-06 0 8.999e-06 0 9e-06 1.8 9.999e-06 1.8 1e-05 0 1.0999e-05 0 1.1e-05 1.8 1.1999e-05 1.8 1.2e-05 0 1.2999e-05 0 1.3e-05 1.8 1.3999e-05 1.8 1.4e-05 0 1.4999e-05 0 1.5e-05 1.8 1.5999e-05 1.8 1.6e-05 0 1.6999e-05 0 1.7e-05 1.8 1.7999e-05 1.8 1.8e-05 0 1.8999e-05 0 1.9e-05 1.8 1.9999e-05 1.8 2e-05 0 2.0999e-05 0 2.1e-05 1.8 2.1999e-05 1.8 2.2e-05 0 2.2999e-05 0 2.3e-05 1.8 2.3999e-05 1.8 2.4e-05 0 2.4999e-05 0 2.5e-05 1.8 2.5999e-05 1.8 2.6e-05 0 2.6999e-05 0 2.7e-05 1.8 2.7999e-05 1.8 2.8e-05 0 2.8999e-05 0 2.9e-05 1.8 2.9999e-05 1.8 3e-05 0 3.0999e-05 0 3.1e-05 1.8 3.1999e-05 1.8 3.2e-05 0 3.2999e-05 0 3.3e-05 1.8 3.3999e-05 1.8 3.4e-05 0 3.4999e-05 0 3.5e-05 1.8 3.5999e-05 1.8 3.6e-05 0 3.6999e-05 0 3.7e-05 1.8 3.7999e-05 1.8 3.8e-05 0 3.8999e-05 0 3.9e-05 1.8 3.9999e-05 1.8 4e-05 0 4.0999e-05 0 4.1e-05 1.8 4.1999e-05 1.8 4.2e-05 0 4.2999e-05 0 4.3e-05 1.8 4.3999e-05 1.8 4.4e-05 0 4.4999e-05 0 4.5e-05 1.8 4.5999e-05 1.8 4.6e-05 0 4.6999e-05 0 4.7e-05 1.8 4.7999e-05 1.8 4.8e-05 0 4.8999e-05 0 4.9e-05 1.8 4.9999e-05 1.8 5e-05 0 5.0999e-05 0 5.1e-05 1.8 5.1999e-05 1.8 5.2e-05 0 5.2999e-05 0 5.3e-05 1.8 5.3999e-05 1.8 5.4e-05 0 5.4999e-05 0 5.5e-05 1.8 5.5999e-05 1.8 5.6e-05 0 5.6999e-05 0 5.7e-05 1.8 5.7999e-05 1.8 5.8e-05 0 5.8999e-05 0 5.9e-05 1.8 5.9999e-05 1.8 6e-05 0 6.0999e-05 0 6.1e-05 1.8 6.1999e-05 1.8 6.2e-05 0 6.2999e-05 0 6.3e-05 1.8 6.3999e-05 1.8 6.4e-05 0 6.4999e-05 0 6.5e-05 1.8 6.5999e-05 1.8 6.6e-05 0 6.6999e-05 0 6.7e-05 1.8 6.7999e-05 1.8 6.8e-05 0 6.8999e-05 0 6.9e-05 1.8 6.9999e-05 1.8 7e-05 0 7.0999e-05 0 7.1e-05 1.8 7.1999e-05 1.8 7.2e-05 0 7.2999e-05 0 7.3e-05 1.8 7.3999e-05 1.8 7.4e-05 0 7.4999e-05 0 7.5e-05 1.8 7.5999e-05 1.8 7.6e-05 0 7.6999e-05 0 7.7e-05 1.8 7.7999e-05 1.8 7.8e-05 0 7.8999e-05 0 7.9e-05 1.8 7.9999e-05 1.8 8e-05 0 8.0999e-05 0 8.1e-05 1.8 8.1999e-05 1.8 8.2e-05 0 8.2999e-05 0 8.3e-05 1.8 8.3999e-05 1.8 8.4e-05 0 8.4999e-05 0 8.5e-05 1.8 8.5999e-05 1.8 8.6e-05 0 8.6999e-05 0 8.7e-05 1.8 8.7999e-05 1.8 8.8e-05 0 8.8999e-05 0 8.9e-05 1.8 8.9999e-05 1.8 9e-05 0 9.0999e-05 0 9.1e-05 1.8 9.1999e-05 1.8 9.2e-05 0 9.2999e-05 0 9.3e-05 1.8 9.3999e-05 1.8 9.4e-05 0 9.4999e-05 0 9.5e-05 1.8 9.5999e-05 1.8 9.6e-05 0 9.6999e-05 0 9.7e-05 1.8 9.7999e-05 1.8 9.8e-05 0 9.8999e-05 0 9.9e-05 1.8 9.9999e-05 1.8 0.0001 0 0.000100999 0 0.000101 1.8 0.000101999 1.8 0.000102 0 0.000102999 0 0.000103 1.8 0.000103999 1.8 0.000104 0 0.000104999 0 0.000105 1.8 0.000105999 1.8 0.000106 0 0.000106999 0 0.000107 1.8 0.000107999 1.8 0.000108 0 0.000108999 0 0.000109 1.8 0.000109999 1.8 0.00011 0 0.000110999 0 0.000111 1.8 0.000111999 1.8 0.000112 0 0.000112999 0 0.000113 1.8 0.000113999 1.8 0.000114 0 0.000114999 0 0.000115 1.8 0.000115999 1.8 0.000116 0 0.000116999 0 0.000117 1.8 0.000117999 1.8 0.000118 0 0.000118999 0 0.000119 1.8 0.000119999 1.8 0.00012 0 0.000120999 0 0.000121 1.8 0.000121999 1.8 0.000122 0 0.000122999 0 0.000123 1.8 0.000123999 1.8 0.000124 0 0.000124999 0 0.000125 1.8 0.000125999 1.8 0.000126 0 0.000126999 0 0.000127 1.8 0.000127999 1.8 0.000128 0 0.000128999 0 0.000129 1.8 0.000129999 1.8 0.00013 0 0.000130999 0 0.000131 1.8 0.000131999 1.8 0.000132 0 0.000132999 0 0.000133 1.8 0.000133999 1.8 0.000134 0 0.000134999 0 0.000135 1.8 0.000135999 1.8 0.000136 0 0.000136999 0 0.000137 1.8 0.000137999 1.8 0.000138 0 0.000138999 0 0.000139 1.8 0.000139999 1.8 0.00014 0 0.000140999 0 0.000141 1.8 0.000141999 1.8 0.000142 0 0.000142999 0 0.000143 1.8 0.000143999 1.8 0.000144 0 0.000144999 0 0.000145 1.8 0.000145999 1.8 0.000146 0 0.000146999 0 0.000147 1.8 0.000147999 1.8 0.000148 0 0.000148999 0 0.000149 1.8 0.000149999 1.8 0.00015 0 0.000150999 0 0.000151 1.8 0.000151999 1.8 0.000152 0 0.000152999 0 0.000153 1.8 0.000153999 1.8 0.000154 0 0.000154999 0 0.000155 1.8 0.000155999 1.8 0.000156 0 0.000156999 0 0.000157 1.8 0.000157999 1.8 0.000158 0 0.000158999 0 0.000159 1.8 0.000159999 1.8 0.00016 0 0.000160999 0 0.000161 1.8 0.000161999 1.8 0.000162 0 0.000162999 0 0.000163 1.8 0.000163999 1.8 0.000164 0 0.000164999 0 0.000165 1.8 0.000165999 1.8 0.000166 0 0.000166999 0 0.000167 1.8 0.000167999 1.8 0.000168 0 0.000168999 0 0.000169 1.8 0.000169999 1.8 0.00017 0 0.000170999 0 0.000171 1.8 0.000171999 1.8 0.000172 0 0.000172999 0 0.000173 1.8 0.000173999 1.8 0.000174 0 0.000174999 0 0.000175 1.8 0.000175999 1.8 0.000176 0 0.000176999 0 0.000177 1.8 0.000177999 1.8 0.000178 0 0.000178999 0 0.000179 1.8 0.000179999 1.8 0.00018 0 0.000180999 0 0.000181 1.8 0.000181999 1.8 0.000182 0 0.000182999 0 0.000183 1.8 0.000183999 1.8 0.000184 0 0.000184999 0 0.000185 1.8 0.000185999 1.8 0.000186 0 0.000186999 0 0.000187 1.8 0.000187999 1.8 0.000188 0 0.000188999 0 0.000189 1.8 0.000189999 1.8 0.00019 0 0.000190999 0 0.000191 1.8 0.000191999 1.8 0.000192 0 0.000192999 0 0.000193 1.8 0.000193999 1.8 0.000194 0 0.000194999 0 0.000195 1.8 0.000195999 1.8 0.000196 0 0.000196999 0 0.000197 1.8 0.000197999 1.8 0.000198 0 0.000198999 0 0.000199 1.8 0.000199999 1.8 0.0002 0 0.000200999 0 0.000201 1.8 0.000201999 1.8 0.000202 0 0.000202999 0 0.000203 1.8 0.000203999 1.8 0.000204 0 0.000204999 0 0.000205 1.8 0.000205999 1.8 0.000206 0 0.000206999 0 0.000207 1.8 0.000207999 1.8 0.000208 0 0.000208999 0 0.000209 1.8 0.000209999 1.8 0.00021 0 0.000210999 0 0.000211 1.8 0.000211999 1.8 0.000212 0 0.000212999 0 0.000213 1.8 0.000213999 1.8 0.000214 0 0.000214999 0 0.000215 1.8 0.000215999 1.8 0.000216 0 0.000216999 0 0.000217 1.8 0.000217999 1.8 0.000218 0 0.000218999 0 0.000219 1.8 0.000219999 1.8 0.00022 0 0.000220999 0 0.000221 1.8 0.000221999 1.8 0.000222 0 0.000222999 0 0.000223 1.8 0.000223999 1.8 0.000224 0 0.000224999 0 0.000225 1.8 0.000225999 1.8 0.000226 0 0.000226999 0 0.000227 1.8 0.000227999 1.8 0.000228 0 0.000228999 0 0.000229 1.8 0.000229999 1.8 0.00023 0 0.000230999 0 0.000231 1.8 0.000231999 1.8 0.000232 0 0.000232999 0 0.000233 1.8 0.000233999 1.8 0.000234 0 0.000234999 0 0.000235 1.8 0.000235999 1.8 0.000236 0 0.000236999 0 0.000237 1.8 0.000237999 1.8 0.000238 0 0.000238999 0 0.000239 1.8 0.000239999 1.8 0.00024 0 0.000240999 0 0.000241 1.8 0.000241999 1.8 0.000242 0 0.000242999 0 0.000243 1.8 0.000243999 1.8 0.000244 0 0.000244999 0 0.000245 1.8 0.000245999 1.8 0.000246 0 0.000246999 0 0.000247 1.8 0.000247999 1.8 0.000248 0 0.000248999 0 0.000249 1.8 0.000249999 1.8 0.00025 0 0.000250999 0 0.000251 1.8 0.000251999 1.8 0.000252 0 0.000252999 0 0.000253 1.8 0.000253999 1.8 0.000254 0 0.000254999 0 0.000255 1.8 0.000256 1.8)
V2 B[1] GND PWL(0 0 9.99e-07 0 1e-06 0 1.999e-06 0 2e-06 1.8 2.999e-06 1.8 3e-06 1.8 3.999e-06 1.8 4e-06 0 4.999e-06 0 5e-06 0 5.999e-06 0 6e-06 1.8 6.999e-06 1.8 7e-06 1.8 7.999e-06 1.8 8e-06 0 8.999e-06 0 9e-06 0 9.999e-06 0 1e-05 1.8 1.0999e-05 1.8 1.1e-05 1.8 1.1999e-05 1.8 1.2e-05 0 1.2999e-05 0 1.3e-05 0 1.3999e-05 0 1.4e-05 1.8 1.4999e-05 1.8 1.5e-05 1.8 1.5999e-05 1.8 1.6e-05 0 1.6999e-05 0 1.7e-05 0 1.7999e-05 0 1.8e-05 1.8 1.8999e-05 1.8 1.9e-05 1.8 1.9999e-05 1.8 2e-05 0 2.0999e-05 0 2.1e-05 0 2.1999e-05 0 2.2e-05 1.8 2.2999e-05 1.8 2.3e-05 1.8 2.3999e-05 1.8 2.4e-05 0 2.4999e-05 0 2.5e-05 0 2.5999e-05 0 2.6e-05 1.8 2.6999e-05 1.8 2.7e-05 1.8 2.7999e-05 1.8 2.8e-05 0 2.8999e-05 0 2.9e-05 0 2.9999e-05 0 3e-05 1.8 3.0999e-05 1.8 3.1e-05 1.8 3.1999e-05 1.8 3.2e-05 0 3.2999e-05 0 3.3e-05 0 3.3999e-05 0 3.4e-05 1.8 3.4999e-05 1.8 3.5e-05 1.8 3.5999e-05 1.8 3.6e-05 0 3.6999e-05 0 3.7e-05 0 3.7999e-05 0 3.8e-05 1.8 3.8999e-05 1.8 3.9e-05 1.8 3.9999e-05 1.8 4e-05 0 4.0999e-05 0 4.1e-05 0 4.1999e-05 0 4.2e-05 1.8 4.2999e-05 1.8 4.3e-05 1.8 4.3999e-05 1.8 4.4e-05 0 4.4999e-05 0 4.5e-05 0 4.5999e-05 0 4.6e-05 1.8 4.6999e-05 1.8 4.7e-05 1.8 4.7999e-05 1.8 4.8e-05 0 4.8999e-05 0 4.9e-05 0 4.9999e-05 0 5e-05 1.8 5.0999e-05 1.8 5.1e-05 1.8 5.1999e-05 1.8 5.2e-05 0 5.2999e-05 0 5.3e-05 0 5.3999e-05 0 5.4e-05 1.8 5.4999e-05 1.8 5.5e-05 1.8 5.5999e-05 1.8 5.6e-05 0 5.6999e-05 0 5.7e-05 0 5.7999e-05 0 5.8e-05 1.8 5.8999e-05 1.8 5.9e-05 1.8 5.9999e-05 1.8 6e-05 0 6.0999e-05 0 6.1e-05 0 6.1999e-05 0 6.2e-05 1.8 6.2999e-05 1.8 6.3e-05 1.8 6.3999e-05 1.8 6.4e-05 0 6.4999e-05 0 6.5e-05 0 6.5999e-05 0 6.6e-05 1.8 6.6999e-05 1.8 6.7e-05 1.8 6.7999e-05 1.8 6.8e-05 0 6.8999e-05 0 6.9e-05 0 6.9999e-05 0 7e-05 1.8 7.0999e-05 1.8 7.1e-05 1.8 7.1999e-05 1.8 7.2e-05 0 7.2999e-05 0 7.3e-05 0 7.3999e-05 0 7.4e-05 1.8 7.4999e-05 1.8 7.5e-05 1.8 7.5999e-05 1.8 7.6e-05 0 7.6999e-05 0 7.7e-05 0 7.7999e-05 0 7.8e-05 1.8 7.8999e-05 1.8 7.9e-05 1.8 7.9999e-05 1.8 8e-05 0 8.0999e-05 0 8.1e-05 0 8.1999e-05 0 8.2e-05 1.8 8.2999e-05 1.8 8.3e-05 1.8 8.3999e-05 1.8 8.4e-05 0 8.4999e-05 0 8.5e-05 0 8.5999e-05 0 8.6e-05 1.8 8.6999e-05 1.8 8.7e-05 1.8 8.7999e-05 1.8 8.8e-05 0 8.8999e-05 0 8.9e-05 0 8.9999e-05 0 9e-05 1.8 9.0999e-05 1.8 9.1e-05 1.8 9.1999e-05 1.8 9.2e-05 0 9.2999e-05 0 9.3e-05 0 9.3999e-05 0 9.4e-05 1.8 9.4999e-05 1.8 9.5e-05 1.8 9.5999e-05 1.8 9.6e-05 0 9.6999e-05 0 9.7e-05 0 9.7999e-05 0 9.8e-05 1.8 9.8999e-05 1.8 9.9e-05 1.8 9.9999e-05 1.8 0.0001 0 0.000100999 0 0.000101 0 0.000101999 0 0.000102 1.8 0.000102999 1.8 0.000103 1.8 0.000103999 1.8 0.000104 0 0.000104999 0 0.000105 0 0.000105999 0 0.000106 1.8 0.000106999 1.8 0.000107 1.8 0.000107999 1.8 0.000108 0 0.000108999 0 0.000109 0 0.000109999 0 0.00011 1.8 0.000110999 1.8 0.000111 1.8 0.000111999 1.8 0.000112 0 0.000112999 0 0.000113 0 0.000113999 0 0.000114 1.8 0.000114999 1.8 0.000115 1.8 0.000115999 1.8 0.000116 0 0.000116999 0 0.000117 0 0.000117999 0 0.000118 1.8 0.000118999 1.8 0.000119 1.8 0.000119999 1.8 0.00012 0 0.000120999 0 0.000121 0 0.000121999 0 0.000122 1.8 0.000122999 1.8 0.000123 1.8 0.000123999 1.8 0.000124 0 0.000124999 0 0.000125 0 0.000125999 0 0.000126 1.8 0.000126999 1.8 0.000127 1.8 0.000127999 1.8 0.000128 0 0.000128999 0 0.000129 0 0.000129999 0 0.00013 1.8 0.000130999 1.8 0.000131 1.8 0.000131999 1.8 0.000132 0 0.000132999 0 0.000133 0 0.000133999 0 0.000134 1.8 0.000134999 1.8 0.000135 1.8 0.000135999 1.8 0.000136 0 0.000136999 0 0.000137 0 0.000137999 0 0.000138 1.8 0.000138999 1.8 0.000139 1.8 0.000139999 1.8 0.00014 0 0.000140999 0 0.000141 0 0.000141999 0 0.000142 1.8 0.000142999 1.8 0.000143 1.8 0.000143999 1.8 0.000144 0 0.000144999 0 0.000145 0 0.000145999 0 0.000146 1.8 0.000146999 1.8 0.000147 1.8 0.000147999 1.8 0.000148 0 0.000148999 0 0.000149 0 0.000149999 0 0.00015 1.8 0.000150999 1.8 0.000151 1.8 0.000151999 1.8 0.000152 0 0.000152999 0 0.000153 0 0.000153999 0 0.000154 1.8 0.000154999 1.8 0.000155 1.8 0.000155999 1.8 0.000156 0 0.000156999 0 0.000157 0 0.000157999 0 0.000158 1.8 0.000158999 1.8 0.000159 1.8 0.000159999 1.8 0.00016 0 0.000160999 0 0.000161 0 0.000161999 0 0.000162 1.8 0.000162999 1.8 0.000163 1.8 0.000163999 1.8 0.000164 0 0.000164999 0 0.000165 0 0.000165999 0 0.000166 1.8 0.000166999 1.8 0.000167 1.8 0.000167999 1.8 0.000168 0 0.000168999 0 0.000169 0 0.000169999 0 0.00017 1.8 0.000170999 1.8 0.000171 1.8 0.000171999 1.8 0.000172 0 0.000172999 0 0.000173 0 0.000173999 0 0.000174 1.8 0.000174999 1.8 0.000175 1.8 0.000175999 1.8 0.000176 0 0.000176999 0 0.000177 0 0.000177999 0 0.000178 1.8 0.000178999 1.8 0.000179 1.8 0.000179999 1.8 0.00018 0 0.000180999 0 0.000181 0 0.000181999 0 0.000182 1.8 0.000182999 1.8 0.000183 1.8 0.000183999 1.8 0.000184 0 0.000184999 0 0.000185 0 0.000185999 0 0.000186 1.8 0.000186999 1.8 0.000187 1.8 0.000187999 1.8 0.000188 0 0.000188999 0 0.000189 0 0.000189999 0 0.00019 1.8 0.000190999 1.8 0.000191 1.8 0.000191999 1.8 0.000192 0 0.000192999 0 0.000193 0 0.000193999 0 0.000194 1.8 0.000194999 1.8 0.000195 1.8 0.000195999 1.8 0.000196 0 0.000196999 0 0.000197 0 0.000197999 0 0.000198 1.8 0.000198999 1.8 0.000199 1.8 0.000199999 1.8 0.0002 0 0.000200999 0 0.000201 0 0.000201999 0 0.000202 1.8 0.000202999 1.8 0.000203 1.8 0.000203999 1.8 0.000204 0 0.000204999 0 0.000205 0 0.000205999 0 0.000206 1.8 0.000206999 1.8 0.000207 1.8 0.000207999 1.8 0.000208 0 0.000208999 0 0.000209 0 0.000209999 0 0.00021 1.8 0.000210999 1.8 0.000211 1.8 0.000211999 1.8 0.000212 0 0.000212999 0 0.000213 0 0.000213999 0 0.000214 1.8 0.000214999 1.8 0.000215 1.8 0.000215999 1.8 0.000216 0 0.000216999 0 0.000217 0 0.000217999 0 0.000218 1.8 0.000218999 1.8 0.000219 1.8 0.000219999 1.8 0.00022 0 0.000220999 0 0.000221 0 0.000221999 0 0.000222 1.8 0.000222999 1.8 0.000223 1.8 0.000223999 1.8 0.000224 0 0.000224999 0 0.000225 0 0.000225999 0 0.000226 1.8 0.000226999 1.8 0.000227 1.8 0.000227999 1.8 0.000228 0 0.000228999 0 0.000229 0 0.000229999 0 0.00023 1.8 0.000230999 1.8 0.000231 1.8 0.000231999 1.8 0.000232 0 0.000232999 0 0.000233 0 0.000233999 0 0.000234 1.8 0.000234999 1.8 0.000235 1.8 0.000235999 1.8 0.000236 0 0.000236999 0 0.000237 0 0.000237999 0 0.000238 1.8 0.000238999 1.8 0.000239 1.8 0.000239999 1.8 0.00024 0 0.000240999 0 0.000241 0 0.000241999 0 0.000242 1.8 0.000242999 1.8 0.000243 1.8 0.000243999 1.8 0.000244 0 0.000244999 0 0.000245 0 0.000245999 0 0.000246 1.8 0.000246999 1.8 0.000247 1.8 0.000247999 1.8 0.000248 0 0.000248999 0 0.000249 0 0.000249999 0 0.00025 1.8 0.000250999 1.8 0.000251 1.8 0.000251999 1.8 0.000252 0 0.000252999 0 0.000253 0 0.000253999 0 0.000254 1.8 0.000254999 1.8 0.000255 1.8 0.000256 1.8)
V3 B[2] GND PWL(0 0 9.99e-07 0 1e-06 0 1.999e-06 0 2e-06 0 2.999e-06 0 3e-06 0 3.999e-06 0 4e-06 1.8 4.999e-06 1.8 5e-06 1.8 5.999e-06 1.8 6e-06 1.8 6.999e-06 1.8 7e-06 1.8 7.999e-06 1.8 8e-06 0 8.999e-06 0 9e-06 0 9.999e-06 0 1e-05 0 1.0999e-05 0 1.1e-05 0 1.1999e-05 0 1.2e-05 1.8 1.2999e-05 1.8 1.3e-05 1.8 1.3999e-05 1.8 1.4e-05 1.8 1.4999e-05 1.8 1.5e-05 1.8 1.5999e-05 1.8 1.6e-05 0 1.6999e-05 0 1.7e-05 0 1.7999e-05 0 1.8e-05 0 1.8999e-05 0 1.9e-05 0 1.9999e-05 0 2e-05 1.8 2.0999e-05 1.8 2.1e-05 1.8 2.1999e-05 1.8 2.2e-05 1.8 2.2999e-05 1.8 2.3e-05 1.8 2.3999e-05 1.8 2.4e-05 0 2.4999e-05 0 2.5e-05 0 2.5999e-05 0 2.6e-05 0 2.6999e-05 0 2.7e-05 0 2.7999e-05 0 2.8e-05 1.8 2.8999e-05 1.8 2.9e-05 1.8 2.9999e-05 1.8 3e-05 1.8 3.0999e-05 1.8 3.1e-05 1.8 3.1999e-05 1.8 3.2e-05 0 3.2999e-05 0 3.3e-05 0 3.3999e-05 0 3.4e-05 0 3.4999e-05 0 3.5e-05 0 3.5999e-05 0 3.6e-05 1.8 3.6999e-05 1.8 3.7e-05 1.8 3.7999e-05 1.8 3.8e-05 1.8 3.8999e-05 1.8 3.9e-05 1.8 3.9999e-05 1.8 4e-05 0 4.0999e-05 0 4.1e-05 0 4.1999e-05 0 4.2e-05 0 4.2999e-05 0 4.3e-05 0 4.3999e-05 0 4.4e-05 1.8 4.4999e-05 1.8 4.5e-05 1.8 4.5999e-05 1.8 4.6e-05 1.8 4.6999e-05 1.8 4.7e-05 1.8 4.7999e-05 1.8 4.8e-05 0 4.8999e-05 0 4.9e-05 0 4.9999e-05 0 5e-05 0 5.0999e-05 0 5.1e-05 0 5.1999e-05 0 5.2e-05 1.8 5.2999e-05 1.8 5.3e-05 1.8 5.3999e-05 1.8 5.4e-05 1.8 5.4999e-05 1.8 5.5e-05 1.8 5.5999e-05 1.8 5.6e-05 0 5.6999e-05 0 5.7e-05 0 5.7999e-05 0 5.8e-05 0 5.8999e-05 0 5.9e-05 0 5.9999e-05 0 6e-05 1.8 6.0999e-05 1.8 6.1e-05 1.8 6.1999e-05 1.8 6.2e-05 1.8 6.2999e-05 1.8 6.3e-05 1.8 6.3999e-05 1.8 6.4e-05 0 6.4999e-05 0 6.5e-05 0 6.5999e-05 0 6.6e-05 0 6.6999e-05 0 6.7e-05 0 6.7999e-05 0 6.8e-05 1.8 6.8999e-05 1.8 6.9e-05 1.8 6.9999e-05 1.8 7e-05 1.8 7.0999e-05 1.8 7.1e-05 1.8 7.1999e-05 1.8 7.2e-05 0 7.2999e-05 0 7.3e-05 0 7.3999e-05 0 7.4e-05 0 7.4999e-05 0 7.5e-05 0 7.5999e-05 0 7.6e-05 1.8 7.6999e-05 1.8 7.7e-05 1.8 7.7999e-05 1.8 7.8e-05 1.8 7.8999e-05 1.8 7.9e-05 1.8 7.9999e-05 1.8 8e-05 0 8.0999e-05 0 8.1e-05 0 8.1999e-05 0 8.2e-05 0 8.2999e-05 0 8.3e-05 0 8.3999e-05 0 8.4e-05 1.8 8.4999e-05 1.8 8.5e-05 1.8 8.5999e-05 1.8 8.6e-05 1.8 8.6999e-05 1.8 8.7e-05 1.8 8.7999e-05 1.8 8.8e-05 0 8.8999e-05 0 8.9e-05 0 8.9999e-05 0 9e-05 0 9.0999e-05 0 9.1e-05 0 9.1999e-05 0 9.2e-05 1.8 9.2999e-05 1.8 9.3e-05 1.8 9.3999e-05 1.8 9.4e-05 1.8 9.4999e-05 1.8 9.5e-05 1.8 9.5999e-05 1.8 9.6e-05 0 9.6999e-05 0 9.7e-05 0 9.7999e-05 0 9.8e-05 0 9.8999e-05 0 9.9e-05 0 9.9999e-05 0 0.0001 1.8 0.000100999 1.8 0.000101 1.8 0.000101999 1.8 0.000102 1.8 0.000102999 1.8 0.000103 1.8 0.000103999 1.8 0.000104 0 0.000104999 0 0.000105 0 0.000105999 0 0.000106 0 0.000106999 0 0.000107 0 0.000107999 0 0.000108 1.8 0.000108999 1.8 0.000109 1.8 0.000109999 1.8 0.00011 1.8 0.000110999 1.8 0.000111 1.8 0.000111999 1.8 0.000112 0 0.000112999 0 0.000113 0 0.000113999 0 0.000114 0 0.000114999 0 0.000115 0 0.000115999 0 0.000116 1.8 0.000116999 1.8 0.000117 1.8 0.000117999 1.8 0.000118 1.8 0.000118999 1.8 0.000119 1.8 0.000119999 1.8 0.00012 0 0.000120999 0 0.000121 0 0.000121999 0 0.000122 0 0.000122999 0 0.000123 0 0.000123999 0 0.000124 1.8 0.000124999 1.8 0.000125 1.8 0.000125999 1.8 0.000126 1.8 0.000126999 1.8 0.000127 1.8 0.000127999 1.8 0.000128 0 0.000128999 0 0.000129 0 0.000129999 0 0.00013 0 0.000130999 0 0.000131 0 0.000131999 0 0.000132 1.8 0.000132999 1.8 0.000133 1.8 0.000133999 1.8 0.000134 1.8 0.000134999 1.8 0.000135 1.8 0.000135999 1.8 0.000136 0 0.000136999 0 0.000137 0 0.000137999 0 0.000138 0 0.000138999 0 0.000139 0 0.000139999 0 0.00014 1.8 0.000140999 1.8 0.000141 1.8 0.000141999 1.8 0.000142 1.8 0.000142999 1.8 0.000143 1.8 0.000143999 1.8 0.000144 0 0.000144999 0 0.000145 0 0.000145999 0 0.000146 0 0.000146999 0 0.000147 0 0.000147999 0 0.000148 1.8 0.000148999 1.8 0.000149 1.8 0.000149999 1.8 0.00015 1.8 0.000150999 1.8 0.000151 1.8 0.000151999 1.8 0.000152 0 0.000152999 0 0.000153 0 0.000153999 0 0.000154 0 0.000154999 0 0.000155 0 0.000155999 0 0.000156 1.8 0.000156999 1.8 0.000157 1.8 0.000157999 1.8 0.000158 1.8 0.000158999 1.8 0.000159 1.8 0.000159999 1.8 0.00016 0 0.000160999 0 0.000161 0 0.000161999 0 0.000162 0 0.000162999 0 0.000163 0 0.000163999 0 0.000164 1.8 0.000164999 1.8 0.000165 1.8 0.000165999 1.8 0.000166 1.8 0.000166999 1.8 0.000167 1.8 0.000167999 1.8 0.000168 0 0.000168999 0 0.000169 0 0.000169999 0 0.00017 0 0.000170999 0 0.000171 0 0.000171999 0 0.000172 1.8 0.000172999 1.8 0.000173 1.8 0.000173999 1.8 0.000174 1.8 0.000174999 1.8 0.000175 1.8 0.000175999 1.8 0.000176 0 0.000176999 0 0.000177 0 0.000177999 0 0.000178 0 0.000178999 0 0.000179 0 0.000179999 0 0.00018 1.8 0.000180999 1.8 0.000181 1.8 0.000181999 1.8 0.000182 1.8 0.000182999 1.8 0.000183 1.8 0.000183999 1.8 0.000184 0 0.000184999 0 0.000185 0 0.000185999 0 0.000186 0 0.000186999 0 0.000187 0 0.000187999 0 0.000188 1.8 0.000188999 1.8 0.000189 1.8 0.000189999 1.8 0.00019 1.8 0.000190999 1.8 0.000191 1.8 0.000191999 1.8 0.000192 0 0.000192999 0 0.000193 0 0.000193999 0 0.000194 0 0.000194999 0 0.000195 0 0.000195999 0 0.000196 1.8 0.000196999 1.8 0.000197 1.8 0.000197999 1.8 0.000198 1.8 0.000198999 1.8 0.000199 1.8 0.000199999 1.8 0.0002 0 0.000200999 0 0.000201 0 0.000201999 0 0.000202 0 0.000202999 0 0.000203 0 0.000203999 0 0.000204 1.8 0.000204999 1.8 0.000205 1.8 0.000205999 1.8 0.000206 1.8 0.000206999 1.8 0.000207 1.8 0.000207999 1.8 0.000208 0 0.000208999 0 0.000209 0 0.000209999 0 0.00021 0 0.000210999 0 0.000211 0 0.000211999 0 0.000212 1.8 0.000212999 1.8 0.000213 1.8 0.000213999 1.8 0.000214 1.8 0.000214999 1.8 0.000215 1.8 0.000215999 1.8 0.000216 0 0.000216999 0 0.000217 0 0.000217999 0 0.000218 0 0.000218999 0 0.000219 0 0.000219999 0 0.00022 1.8 0.000220999 1.8 0.000221 1.8 0.000221999 1.8 0.000222 1.8 0.000222999 1.8 0.000223 1.8 0.000223999 1.8 0.000224 0 0.000224999 0 0.000225 0 0.000225999 0 0.000226 0 0.000226999 0 0.000227 0 0.000227999 0 0.000228 1.8 0.000228999 1.8 0.000229 1.8 0.000229999 1.8 0.00023 1.8 0.000230999 1.8 0.000231 1.8 0.000231999 1.8 0.000232 0 0.000232999 0 0.000233 0 0.000233999 0 0.000234 0 0.000234999 0 0.000235 0 0.000235999 0 0.000236 1.8 0.000236999 1.8 0.000237 1.8 0.000237999 1.8 0.000238 1.8 0.000238999 1.8 0.000239 1.8 0.000239999 1.8 0.00024 0 0.000240999 0 0.000241 0 0.000241999 0 0.000242 0 0.000242999 0 0.000243 0 0.000243999 0 0.000244 1.8 0.000244999 1.8 0.000245 1.8 0.000245999 1.8 0.000246 1.8 0.000246999 1.8 0.000247 1.8 0.000247999 1.8 0.000248 0 0.000248999 0 0.000249 0 0.000249999 0 0.00025 0 0.000250999 0 0.000251 0 0.000251999 0 0.000252 1.8 0.000252999 1.8 0.000253 1.8 0.000253999 1.8 0.000254 1.8 0.000254999 1.8 0.000255 1.8 0.000256 1.8)
V4 B[3] GND PWL(0 0 9.99e-07 0 1e-06 0 1.999e-06 0 2e-06 0 2.999e-06 0 3e-06 0 3.999e-06 0 4e-06 0 4.999e-06 0 5e-06 0 5.999e-06 0 6e-06 0 6.999e-06 0 7e-06 0 7.999e-06 0 8e-06 1.8 8.999e-06 1.8 9e-06 1.8 9.999e-06 1.8 1e-05 1.8 1.0999e-05 1.8 1.1e-05 1.8 1.1999e-05 1.8 1.2e-05 1.8 1.2999e-05 1.8 1.3e-05 1.8 1.3999e-05 1.8 1.4e-05 1.8 1.4999e-05 1.8 1.5e-05 1.8 1.5999e-05 1.8 1.6e-05 0 1.6999e-05 0 1.7e-05 0 1.7999e-05 0 1.8e-05 0 1.8999e-05 0 1.9e-05 0 1.9999e-05 0 2e-05 0 2.0999e-05 0 2.1e-05 0 2.1999e-05 0 2.2e-05 0 2.2999e-05 0 2.3e-05 0 2.3999e-05 0 2.4e-05 1.8 2.4999e-05 1.8 2.5e-05 1.8 2.5999e-05 1.8 2.6e-05 1.8 2.6999e-05 1.8 2.7e-05 1.8 2.7999e-05 1.8 2.8e-05 1.8 2.8999e-05 1.8 2.9e-05 1.8 2.9999e-05 1.8 3e-05 1.8 3.0999e-05 1.8 3.1e-05 1.8 3.1999e-05 1.8 3.2e-05 0 3.2999e-05 0 3.3e-05 0 3.3999e-05 0 3.4e-05 0 3.4999e-05 0 3.5e-05 0 3.5999e-05 0 3.6e-05 0 3.6999e-05 0 3.7e-05 0 3.7999e-05 0 3.8e-05 0 3.8999e-05 0 3.9e-05 0 3.9999e-05 0 4e-05 1.8 4.0999e-05 1.8 4.1e-05 1.8 4.1999e-05 1.8 4.2e-05 1.8 4.2999e-05 1.8 4.3e-05 1.8 4.3999e-05 1.8 4.4e-05 1.8 4.4999e-05 1.8 4.5e-05 1.8 4.5999e-05 1.8 4.6e-05 1.8 4.6999e-05 1.8 4.7e-05 1.8 4.7999e-05 1.8 4.8e-05 0 4.8999e-05 0 4.9e-05 0 4.9999e-05 0 5e-05 0 5.0999e-05 0 5.1e-05 0 5.1999e-05 0 5.2e-05 0 5.2999e-05 0 5.3e-05 0 5.3999e-05 0 5.4e-05 0 5.4999e-05 0 5.5e-05 0 5.5999e-05 0 5.6e-05 1.8 5.6999e-05 1.8 5.7e-05 1.8 5.7999e-05 1.8 5.8e-05 1.8 5.8999e-05 1.8 5.9e-05 1.8 5.9999e-05 1.8 6e-05 1.8 6.0999e-05 1.8 6.1e-05 1.8 6.1999e-05 1.8 6.2e-05 1.8 6.2999e-05 1.8 6.3e-05 1.8 6.3999e-05 1.8 6.4e-05 0 6.4999e-05 0 6.5e-05 0 6.5999e-05 0 6.6e-05 0 6.6999e-05 0 6.7e-05 0 6.7999e-05 0 6.8e-05 0 6.8999e-05 0 6.9e-05 0 6.9999e-05 0 7e-05 0 7.0999e-05 0 7.1e-05 0 7.1999e-05 0 7.2e-05 1.8 7.2999e-05 1.8 7.3e-05 1.8 7.3999e-05 1.8 7.4e-05 1.8 7.4999e-05 1.8 7.5e-05 1.8 7.5999e-05 1.8 7.6e-05 1.8 7.6999e-05 1.8 7.7e-05 1.8 7.7999e-05 1.8 7.8e-05 1.8 7.8999e-05 1.8 7.9e-05 1.8 7.9999e-05 1.8 8e-05 0 8.0999e-05 0 8.1e-05 0 8.1999e-05 0 8.2e-05 0 8.2999e-05 0 8.3e-05 0 8.3999e-05 0 8.4e-05 0 8.4999e-05 0 8.5e-05 0 8.5999e-05 0 8.6e-05 0 8.6999e-05 0 8.7e-05 0 8.7999e-05 0 8.8e-05 1.8 8.8999e-05 1.8 8.9e-05 1.8 8.9999e-05 1.8 9e-05 1.8 9.0999e-05 1.8 9.1e-05 1.8 9.1999e-05 1.8 9.2e-05 1.8 9.2999e-05 1.8 9.3e-05 1.8 9.3999e-05 1.8 9.4e-05 1.8 9.4999e-05 1.8 9.5e-05 1.8 9.5999e-05 1.8 9.6e-05 0 9.6999e-05 0 9.7e-05 0 9.7999e-05 0 9.8e-05 0 9.8999e-05 0 9.9e-05 0 9.9999e-05 0 0.0001 0 0.000100999 0 0.000101 0 0.000101999 0 0.000102 0 0.000102999 0 0.000103 0 0.000103999 0 0.000104 1.8 0.000104999 1.8 0.000105 1.8 0.000105999 1.8 0.000106 1.8 0.000106999 1.8 0.000107 1.8 0.000107999 1.8 0.000108 1.8 0.000108999 1.8 0.000109 1.8 0.000109999 1.8 0.00011 1.8 0.000110999 1.8 0.000111 1.8 0.000111999 1.8 0.000112 0 0.000112999 0 0.000113 0 0.000113999 0 0.000114 0 0.000114999 0 0.000115 0 0.000115999 0 0.000116 0 0.000116999 0 0.000117 0 0.000117999 0 0.000118 0 0.000118999 0 0.000119 0 0.000119999 0 0.00012 1.8 0.000120999 1.8 0.000121 1.8 0.000121999 1.8 0.000122 1.8 0.000122999 1.8 0.000123 1.8 0.000123999 1.8 0.000124 1.8 0.000124999 1.8 0.000125 1.8 0.000125999 1.8 0.000126 1.8 0.000126999 1.8 0.000127 1.8 0.000127999 1.8 0.000128 0 0.000128999 0 0.000129 0 0.000129999 0 0.00013 0 0.000130999 0 0.000131 0 0.000131999 0 0.000132 0 0.000132999 0 0.000133 0 0.000133999 0 0.000134 0 0.000134999 0 0.000135 0 0.000135999 0 0.000136 1.8 0.000136999 1.8 0.000137 1.8 0.000137999 1.8 0.000138 1.8 0.000138999 1.8 0.000139 1.8 0.000139999 1.8 0.00014 1.8 0.000140999 1.8 0.000141 1.8 0.000141999 1.8 0.000142 1.8 0.000142999 1.8 0.000143 1.8 0.000143999 1.8 0.000144 0 0.000144999 0 0.000145 0 0.000145999 0 0.000146 0 0.000146999 0 0.000147 0 0.000147999 0 0.000148 0 0.000148999 0 0.000149 0 0.000149999 0 0.00015 0 0.000150999 0 0.000151 0 0.000151999 0 0.000152 1.8 0.000152999 1.8 0.000153 1.8 0.000153999 1.8 0.000154 1.8 0.000154999 1.8 0.000155 1.8 0.000155999 1.8 0.000156 1.8 0.000156999 1.8 0.000157 1.8 0.000157999 1.8 0.000158 1.8 0.000158999 1.8 0.000159 1.8 0.000159999 1.8 0.00016 0 0.000160999 0 0.000161 0 0.000161999 0 0.000162 0 0.000162999 0 0.000163 0 0.000163999 0 0.000164 0 0.000164999 0 0.000165 0 0.000165999 0 0.000166 0 0.000166999 0 0.000167 0 0.000167999 0 0.000168 1.8 0.000168999 1.8 0.000169 1.8 0.000169999 1.8 0.00017 1.8 0.000170999 1.8 0.000171 1.8 0.000171999 1.8 0.000172 1.8 0.000172999 1.8 0.000173 1.8 0.000173999 1.8 0.000174 1.8 0.000174999 1.8 0.000175 1.8 0.000175999 1.8 0.000176 0 0.000176999 0 0.000177 0 0.000177999 0 0.000178 0 0.000178999 0 0.000179 0 0.000179999 0 0.00018 0 0.000180999 0 0.000181 0 0.000181999 0 0.000182 0 0.000182999 0 0.000183 0 0.000183999 0 0.000184 1.8 0.000184999 1.8 0.000185 1.8 0.000185999 1.8 0.000186 1.8 0.000186999 1.8 0.000187 1.8 0.000187999 1.8 0.000188 1.8 0.000188999 1.8 0.000189 1.8 0.000189999 1.8 0.00019 1.8 0.000190999 1.8 0.000191 1.8 0.000191999 1.8 0.000192 0 0.000192999 0 0.000193 0 0.000193999 0 0.000194 0 0.000194999 0 0.000195 0 0.000195999 0 0.000196 0 0.000196999 0 0.000197 0 0.000197999 0 0.000198 0 0.000198999 0 0.000199 0 0.000199999 0 0.0002 1.8 0.000200999 1.8 0.000201 1.8 0.000201999 1.8 0.000202 1.8 0.000202999 1.8 0.000203 1.8 0.000203999 1.8 0.000204 1.8 0.000204999 1.8 0.000205 1.8 0.000205999 1.8 0.000206 1.8 0.000206999 1.8 0.000207 1.8 0.000207999 1.8 0.000208 0 0.000208999 0 0.000209 0 0.000209999 0 0.00021 0 0.000210999 0 0.000211 0 0.000211999 0 0.000212 0 0.000212999 0 0.000213 0 0.000213999 0 0.000214 0 0.000214999 0 0.000215 0 0.000215999 0 0.000216 1.8 0.000216999 1.8 0.000217 1.8 0.000217999 1.8 0.000218 1.8 0.000218999 1.8 0.000219 1.8 0.000219999 1.8 0.00022 1.8 0.000220999 1.8 0.000221 1.8 0.000221999 1.8 0.000222 1.8 0.000222999 1.8 0.000223 1.8 0.000223999 1.8 0.000224 0 0.000224999 0 0.000225 0 0.000225999 0 0.000226 0 0.000226999 0 0.000227 0 0.000227999 0 0.000228 0 0.000228999 0 0.000229 0 0.000229999 0 0.00023 0 0.000230999 0 0.000231 0 0.000231999 0 0.000232 1.8 0.000232999 1.8 0.000233 1.8 0.000233999 1.8 0.000234 1.8 0.000234999 1.8 0.000235 1.8 0.000235999 1.8 0.000236 1.8 0.000236999 1.8 0.000237 1.8 0.000237999 1.8 0.000238 1.8 0.000238999 1.8 0.000239 1.8 0.000239999 1.8 0.00024 0 0.000240999 0 0.000241 0 0.000241999 0 0.000242 0 0.000242999 0 0.000243 0 0.000243999 0 0.000244 0 0.000244999 0 0.000245 0 0.000245999 0 0.000246 0 0.000246999 0 0.000247 0 0.000247999 0 0.000248 1.8 0.000248999 1.8 0.000249 1.8 0.000249999 1.8 0.00025 1.8 0.000250999 1.8 0.000251 1.8 0.000251999 1.8 0.000252 1.8 0.000252999 1.8 0.000253 1.8 0.000253999 1.8 0.000254 1.8 0.000254999 1.8 0.000255 1.8 0.000256 1.8)
V5 B[4] GND PWL(0 0 9.99e-07 0 1e-06 0 1.999e-06 0 2e-06 0 2.999e-06 0 3e-06 0 3.999e-06 0 4e-06 0 4.999e-06 0 5e-06 0 5.999e-06 0 6e-06 0 6.999e-06 0 7e-06 0 7.999e-06 0 8e-06 0 8.999e-06 0 9e-06 0 9.999e-06 0 1e-05 0 1.0999e-05 0 1.1e-05 0 1.1999e-05 0 1.2e-05 0 1.2999e-05 0 1.3e-05 0 1.3999e-05 0 1.4e-05 0 1.4999e-05 0 1.5e-05 0 1.5999e-05 0 1.6e-05 1.8 1.6999e-05 1.8 1.7e-05 1.8 1.7999e-05 1.8 1.8e-05 1.8 1.8999e-05 1.8 1.9e-05 1.8 1.9999e-05 1.8 2e-05 1.8 2.0999e-05 1.8 2.1e-05 1.8 2.1999e-05 1.8 2.2e-05 1.8 2.2999e-05 1.8 2.3e-05 1.8 2.3999e-05 1.8 2.4e-05 1.8 2.4999e-05 1.8 2.5e-05 1.8 2.5999e-05 1.8 2.6e-05 1.8 2.6999e-05 1.8 2.7e-05 1.8 2.7999e-05 1.8 2.8e-05 1.8 2.8999e-05 1.8 2.9e-05 1.8 2.9999e-05 1.8 3e-05 1.8 3.0999e-05 1.8 3.1e-05 1.8 3.1999e-05 1.8 3.2e-05 0 3.2999e-05 0 3.3e-05 0 3.3999e-05 0 3.4e-05 0 3.4999e-05 0 3.5e-05 0 3.5999e-05 0 3.6e-05 0 3.6999e-05 0 3.7e-05 0 3.7999e-05 0 3.8e-05 0 3.8999e-05 0 3.9e-05 0 3.9999e-05 0 4e-05 0 4.0999e-05 0 4.1e-05 0 4.1999e-05 0 4.2e-05 0 4.2999e-05 0 4.3e-05 0 4.3999e-05 0 4.4e-05 0 4.4999e-05 0 4.5e-05 0 4.5999e-05 0 4.6e-05 0 4.6999e-05 0 4.7e-05 0 4.7999e-05 0 4.8e-05 1.8 4.8999e-05 1.8 4.9e-05 1.8 4.9999e-05 1.8 5e-05 1.8 5.0999e-05 1.8 5.1e-05 1.8 5.1999e-05 1.8 5.2e-05 1.8 5.2999e-05 1.8 5.3e-05 1.8 5.3999e-05 1.8 5.4e-05 1.8 5.4999e-05 1.8 5.5e-05 1.8 5.5999e-05 1.8 5.6e-05 1.8 5.6999e-05 1.8 5.7e-05 1.8 5.7999e-05 1.8 5.8e-05 1.8 5.8999e-05 1.8 5.9e-05 1.8 5.9999e-05 1.8 6e-05 1.8 6.0999e-05 1.8 6.1e-05 1.8 6.1999e-05 1.8 6.2e-05 1.8 6.2999e-05 1.8 6.3e-05 1.8 6.3999e-05 1.8 6.4e-05 0 6.4999e-05 0 6.5e-05 0 6.5999e-05 0 6.6e-05 0 6.6999e-05 0 6.7e-05 0 6.7999e-05 0 6.8e-05 0 6.8999e-05 0 6.9e-05 0 6.9999e-05 0 7e-05 0 7.0999e-05 0 7.1e-05 0 7.1999e-05 0 7.2e-05 0 7.2999e-05 0 7.3e-05 0 7.3999e-05 0 7.4e-05 0 7.4999e-05 0 7.5e-05 0 7.5999e-05 0 7.6e-05 0 7.6999e-05 0 7.7e-05 0 7.7999e-05 0 7.8e-05 0 7.8999e-05 0 7.9e-05 0 7.9999e-05 0 8e-05 1.8 8.0999e-05 1.8 8.1e-05 1.8 8.1999e-05 1.8 8.2e-05 1.8 8.2999e-05 1.8 8.3e-05 1.8 8.3999e-05 1.8 8.4e-05 1.8 8.4999e-05 1.8 8.5e-05 1.8 8.5999e-05 1.8 8.6e-05 1.8 8.6999e-05 1.8 8.7e-05 1.8 8.7999e-05 1.8 8.8e-05 1.8 8.8999e-05 1.8 8.9e-05 1.8 8.9999e-05 1.8 9e-05 1.8 9.0999e-05 1.8 9.1e-05 1.8 9.1999e-05 1.8 9.2e-05 1.8 9.2999e-05 1.8 9.3e-05 1.8 9.3999e-05 1.8 9.4e-05 1.8 9.4999e-05 1.8 9.5e-05 1.8 9.5999e-05 1.8 9.6e-05 0 9.6999e-05 0 9.7e-05 0 9.7999e-05 0 9.8e-05 0 9.8999e-05 0 9.9e-05 0 9.9999e-05 0 0.0001 0 0.000100999 0 0.000101 0 0.000101999 0 0.000102 0 0.000102999 0 0.000103 0 0.000103999 0 0.000104 0 0.000104999 0 0.000105 0 0.000105999 0 0.000106 0 0.000106999 0 0.000107 0 0.000107999 0 0.000108 0 0.000108999 0 0.000109 0 0.000109999 0 0.00011 0 0.000110999 0 0.000111 0 0.000111999 0 0.000112 1.8 0.000112999 1.8 0.000113 1.8 0.000113999 1.8 0.000114 1.8 0.000114999 1.8 0.000115 1.8 0.000115999 1.8 0.000116 1.8 0.000116999 1.8 0.000117 1.8 0.000117999 1.8 0.000118 1.8 0.000118999 1.8 0.000119 1.8 0.000119999 1.8 0.00012 1.8 0.000120999 1.8 0.000121 1.8 0.000121999 1.8 0.000122 1.8 0.000122999 1.8 0.000123 1.8 0.000123999 1.8 0.000124 1.8 0.000124999 1.8 0.000125 1.8 0.000125999 1.8 0.000126 1.8 0.000126999 1.8 0.000127 1.8 0.000127999 1.8 0.000128 0 0.000128999 0 0.000129 0 0.000129999 0 0.00013 0 0.000130999 0 0.000131 0 0.000131999 0 0.000132 0 0.000132999 0 0.000133 0 0.000133999 0 0.000134 0 0.000134999 0 0.000135 0 0.000135999 0 0.000136 0 0.000136999 0 0.000137 0 0.000137999 0 0.000138 0 0.000138999 0 0.000139 0 0.000139999 0 0.00014 0 0.000140999 0 0.000141 0 0.000141999 0 0.000142 0 0.000142999 0 0.000143 0 0.000143999 0 0.000144 1.8 0.000144999 1.8 0.000145 1.8 0.000145999 1.8 0.000146 1.8 0.000146999 1.8 0.000147 1.8 0.000147999 1.8 0.000148 1.8 0.000148999 1.8 0.000149 1.8 0.000149999 1.8 0.00015 1.8 0.000150999 1.8 0.000151 1.8 0.000151999 1.8 0.000152 1.8 0.000152999 1.8 0.000153 1.8 0.000153999 1.8 0.000154 1.8 0.000154999 1.8 0.000155 1.8 0.000155999 1.8 0.000156 1.8 0.000156999 1.8 0.000157 1.8 0.000157999 1.8 0.000158 1.8 0.000158999 1.8 0.000159 1.8 0.000159999 1.8 0.00016 0 0.000160999 0 0.000161 0 0.000161999 0 0.000162 0 0.000162999 0 0.000163 0 0.000163999 0 0.000164 0 0.000164999 0 0.000165 0 0.000165999 0 0.000166 0 0.000166999 0 0.000167 0 0.000167999 0 0.000168 0 0.000168999 0 0.000169 0 0.000169999 0 0.00017 0 0.000170999 0 0.000171 0 0.000171999 0 0.000172 0 0.000172999 0 0.000173 0 0.000173999 0 0.000174 0 0.000174999 0 0.000175 0 0.000175999 0 0.000176 1.8 0.000176999 1.8 0.000177 1.8 0.000177999 1.8 0.000178 1.8 0.000178999 1.8 0.000179 1.8 0.000179999 1.8 0.00018 1.8 0.000180999 1.8 0.000181 1.8 0.000181999 1.8 0.000182 1.8 0.000182999 1.8 0.000183 1.8 0.000183999 1.8 0.000184 1.8 0.000184999 1.8 0.000185 1.8 0.000185999 1.8 0.000186 1.8 0.000186999 1.8 0.000187 1.8 0.000187999 1.8 0.000188 1.8 0.000188999 1.8 0.000189 1.8 0.000189999 1.8 0.00019 1.8 0.000190999 1.8 0.000191 1.8 0.000191999 1.8 0.000192 0 0.000192999 0 0.000193 0 0.000193999 0 0.000194 0 0.000194999 0 0.000195 0 0.000195999 0 0.000196 0 0.000196999 0 0.000197 0 0.000197999 0 0.000198 0 0.000198999 0 0.000199 0 0.000199999 0 0.0002 0 0.000200999 0 0.000201 0 0.000201999 0 0.000202 0 0.000202999 0 0.000203 0 0.000203999 0 0.000204 0 0.000204999 0 0.000205 0 0.000205999 0 0.000206 0 0.000206999 0 0.000207 0 0.000207999 0 0.000208 1.8 0.000208999 1.8 0.000209 1.8 0.000209999 1.8 0.00021 1.8 0.000210999 1.8 0.000211 1.8 0.000211999 1.8 0.000212 1.8 0.000212999 1.8 0.000213 1.8 0.000213999 1.8 0.000214 1.8 0.000214999 1.8 0.000215 1.8 0.000215999 1.8 0.000216 1.8 0.000216999 1.8 0.000217 1.8 0.000217999 1.8 0.000218 1.8 0.000218999 1.8 0.000219 1.8 0.000219999 1.8 0.00022 1.8 0.000220999 1.8 0.000221 1.8 0.000221999 1.8 0.000222 1.8 0.000222999 1.8 0.000223 1.8 0.000223999 1.8 0.000224 0 0.000224999 0 0.000225 0 0.000225999 0 0.000226 0 0.000226999 0 0.000227 0 0.000227999 0 0.000228 0 0.000228999 0 0.000229 0 0.000229999 0 0.00023 0 0.000230999 0 0.000231 0 0.000231999 0 0.000232 0 0.000232999 0 0.000233 0 0.000233999 0 0.000234 0 0.000234999 0 0.000235 0 0.000235999 0 0.000236 0 0.000236999 0 0.000237 0 0.000237999 0 0.000238 0 0.000238999 0 0.000239 0 0.000239999 0 0.00024 1.8 0.000240999 1.8 0.000241 1.8 0.000241999 1.8 0.000242 1.8 0.000242999 1.8 0.000243 1.8 0.000243999 1.8 0.000244 1.8 0.000244999 1.8 0.000245 1.8 0.000245999 1.8 0.000246 1.8 0.000246999 1.8 0.000247 1.8 0.000247999 1.8 0.000248 1.8 0.000248999 1.8 0.000249 1.8 0.000249999 1.8 0.00025 1.8 0.000250999 1.8 0.000251 1.8 0.000251999 1.8 0.000252 1.8 0.000252999 1.8 0.000253 1.8 0.000253999 1.8 0.000254 1.8 0.000254999 1.8 0.000255 1.8 0.000256 1.8)
V6 T[0] GND PWL(0 0 9.99e-07 0 1e-06 0 1.999e-06 0 2e-06 0 2.999e-06 0 3e-06 0 3.999e-06 0 4e-06 0 4.999e-06 0 5e-06 0 5.999e-06 0 6e-06 0 6.999e-06 0 7e-06 0 7.999e-06 0 8e-06 0 8.999e-06 0 9e-06 0 9.999e-06 0 1e-05 0 1.0999e-05 0 1.1e-05 0 1.1999e-05 0 1.2e-05 0 1.2999e-05 0 1.3e-05 0 1.3999e-05 0 1.4e-05 0 1.4999e-05 0 1.5e-05 0 1.5999e-05 0 1.6e-05 0 1.6999e-05 0 1.7e-05 0 1.7999e-05 0 1.8e-05 0 1.8999e-05 0 1.9e-05 0 1.9999e-05 0 2e-05 0 2.0999e-05 0 2.1e-05 0 2.1999e-05 0 2.2e-05 0 2.2999e-05 0 2.3e-05 0 2.3999e-05 0 2.4e-05 0 2.4999e-05 0 2.5e-05 0 2.5999e-05 0 2.6e-05 0 2.6999e-05 0 2.7e-05 0 2.7999e-05 0 2.8e-05 0 2.8999e-05 0 2.9e-05 0 2.9999e-05 0 3e-05 0 3.0999e-05 0 3.1e-05 0 3.1999e-05 0 3.2e-05 1.8 3.2999e-05 1.8 3.3e-05 1.8 3.3999e-05 1.8 3.4e-05 1.8 3.4999e-05 1.8 3.5e-05 1.8 3.5999e-05 1.8 3.6e-05 1.8 3.6999e-05 1.8 3.7e-05 1.8 3.7999e-05 1.8 3.8e-05 1.8 3.8999e-05 1.8 3.9e-05 1.8 3.9999e-05 1.8 4e-05 1.8 4.0999e-05 1.8 4.1e-05 1.8 4.1999e-05 1.8 4.2e-05 1.8 4.2999e-05 1.8 4.3e-05 1.8 4.3999e-05 1.8 4.4e-05 1.8 4.4999e-05 1.8 4.5e-05 1.8 4.5999e-05 1.8 4.6e-05 1.8 4.6999e-05 1.8 4.7e-05 1.8 4.7999e-05 1.8 4.8e-05 1.8 4.8999e-05 1.8 4.9e-05 1.8 4.9999e-05 1.8 5e-05 1.8 5.0999e-05 1.8 5.1e-05 1.8 5.1999e-05 1.8 5.2e-05 1.8 5.2999e-05 1.8 5.3e-05 1.8 5.3999e-05 1.8 5.4e-05 1.8 5.4999e-05 1.8 5.5e-05 1.8 5.5999e-05 1.8 5.6e-05 1.8 5.6999e-05 1.8 5.7e-05 1.8 5.7999e-05 1.8 5.8e-05 1.8 5.8999e-05 1.8 5.9e-05 1.8 5.9999e-05 1.8 6e-05 1.8 6.0999e-05 1.8 6.1e-05 1.8 6.1999e-05 1.8 6.2e-05 1.8 6.2999e-05 1.8 6.3e-05 1.8 6.3999e-05 1.8 6.4e-05 1.8 6.4999e-05 1.8 6.5e-05 1.8 6.5999e-05 1.8 6.6e-05 1.8 6.6999e-05 1.8 6.7e-05 1.8 6.7999e-05 1.8 6.8e-05 1.8 6.8999e-05 1.8 6.9e-05 1.8 6.9999e-05 1.8 7e-05 1.8 7.0999e-05 1.8 7.1e-05 1.8 7.1999e-05 1.8 7.2e-05 1.8 7.2999e-05 1.8 7.3e-05 1.8 7.3999e-05 1.8 7.4e-05 1.8 7.4999e-05 1.8 7.5e-05 1.8 7.5999e-05 1.8 7.6e-05 1.8 7.6999e-05 1.8 7.7e-05 1.8 7.7999e-05 1.8 7.8e-05 1.8 7.8999e-05 1.8 7.9e-05 1.8 7.9999e-05 1.8 8e-05 1.8 8.0999e-05 1.8 8.1e-05 1.8 8.1999e-05 1.8 8.2e-05 1.8 8.2999e-05 1.8 8.3e-05 1.8 8.3999e-05 1.8 8.4e-05 1.8 8.4999e-05 1.8 8.5e-05 1.8 8.5999e-05 1.8 8.6e-05 1.8 8.6999e-05 1.8 8.7e-05 1.8 8.7999e-05 1.8 8.8e-05 1.8 8.8999e-05 1.8 8.9e-05 1.8 8.9999e-05 1.8 9e-05 1.8 9.0999e-05 1.8 9.1e-05 1.8 9.1999e-05 1.8 9.2e-05 1.8 9.2999e-05 1.8 9.3e-05 1.8 9.3999e-05 1.8 9.4e-05 1.8 9.4999e-05 1.8 9.5e-05 1.8 9.5999e-05 1.8 9.6e-05 1.8 9.6999e-05 1.8 9.7e-05 1.8 9.7999e-05 1.8 9.8e-05 1.8 9.8999e-05 1.8 9.9e-05 1.8 9.9999e-05 1.8 0.0001 1.8 0.000100999 1.8 0.000101 1.8 0.000101999 1.8 0.000102 1.8 0.000102999 1.8 0.000103 1.8 0.000103999 1.8 0.000104 1.8 0.000104999 1.8 0.000105 1.8 0.000105999 1.8 0.000106 1.8 0.000106999 1.8 0.000107 1.8 0.000107999 1.8 0.000108 1.8 0.000108999 1.8 0.000109 1.8 0.000109999 1.8 0.00011 1.8 0.000110999 1.8 0.000111 1.8 0.000111999 1.8 0.000112 1.8 0.000112999 1.8 0.000113 1.8 0.000113999 1.8 0.000114 1.8 0.000114999 1.8 0.000115 1.8 0.000115999 1.8 0.000116 1.8 0.000116999 1.8 0.000117 1.8 0.000117999 1.8 0.000118 1.8 0.000118999 1.8 0.000119 1.8 0.000119999 1.8 0.00012 1.8 0.000120999 1.8 0.000121 1.8 0.000121999 1.8 0.000122 1.8 0.000122999 1.8 0.000123 1.8 0.000123999 1.8 0.000124 1.8 0.000124999 1.8 0.000125 1.8 0.000125999 1.8 0.000126 1.8 0.000126999 1.8 0.000127 1.8 0.000127999 1.8 0.000128 1.8 0.000128999 1.8 0.000129 1.8 0.000129999 1.8 0.00013 1.8 0.000130999 1.8 0.000131 1.8 0.000131999 1.8 0.000132 1.8 0.000132999 1.8 0.000133 1.8 0.000133999 1.8 0.000134 1.8 0.000134999 1.8 0.000135 1.8 0.000135999 1.8 0.000136 1.8 0.000136999 1.8 0.000137 1.8 0.000137999 1.8 0.000138 1.8 0.000138999 1.8 0.000139 1.8 0.000139999 1.8 0.00014 1.8 0.000140999 1.8 0.000141 1.8 0.000141999 1.8 0.000142 1.8 0.000142999 1.8 0.000143 1.8 0.000143999 1.8 0.000144 1.8 0.000144999 1.8 0.000145 1.8 0.000145999 1.8 0.000146 1.8 0.000146999 1.8 0.000147 1.8 0.000147999 1.8 0.000148 1.8 0.000148999 1.8 0.000149 1.8 0.000149999 1.8 0.00015 1.8 0.000150999 1.8 0.000151 1.8 0.000151999 1.8 0.000152 1.8 0.000152999 1.8 0.000153 1.8 0.000153999 1.8 0.000154 1.8 0.000154999 1.8 0.000155 1.8 0.000155999 1.8 0.000156 1.8 0.000156999 1.8 0.000157 1.8 0.000157999 1.8 0.000158 1.8 0.000158999 1.8 0.000159 1.8 0.000159999 1.8 0.00016 1.8 0.000160999 1.8 0.000161 1.8 0.000161999 1.8 0.000162 1.8 0.000162999 1.8 0.000163 1.8 0.000163999 1.8 0.000164 1.8 0.000164999 1.8 0.000165 1.8 0.000165999 1.8 0.000166 1.8 0.000166999 1.8 0.000167 1.8 0.000167999 1.8 0.000168 1.8 0.000168999 1.8 0.000169 1.8 0.000169999 1.8 0.00017 1.8 0.000170999 1.8 0.000171 1.8 0.000171999 1.8 0.000172 1.8 0.000172999 1.8 0.000173 1.8 0.000173999 1.8 0.000174 1.8 0.000174999 1.8 0.000175 1.8 0.000175999 1.8 0.000176 1.8 0.000176999 1.8 0.000177 1.8 0.000177999 1.8 0.000178 1.8 0.000178999 1.8 0.000179 1.8 0.000179999 1.8 0.00018 1.8 0.000180999 1.8 0.000181 1.8 0.000181999 1.8 0.000182 1.8 0.000182999 1.8 0.000183 1.8 0.000183999 1.8 0.000184 1.8 0.000184999 1.8 0.000185 1.8 0.000185999 1.8 0.000186 1.8 0.000186999 1.8 0.000187 1.8 0.000187999 1.8 0.000188 1.8 0.000188999 1.8 0.000189 1.8 0.000189999 1.8 0.00019 1.8 0.000190999 1.8 0.000191 1.8 0.000191999 1.8 0.000192 1.8 0.000192999 1.8 0.000193 1.8 0.000193999 1.8 0.000194 1.8 0.000194999 1.8 0.000195 1.8 0.000195999 1.8 0.000196 1.8 0.000196999 1.8 0.000197 1.8 0.000197999 1.8 0.000198 1.8 0.000198999 1.8 0.000199 1.8 0.000199999 1.8 0.0002 1.8 0.000200999 1.8 0.000201 1.8 0.000201999 1.8 0.000202 1.8 0.000202999 1.8 0.000203 1.8 0.000203999 1.8 0.000204 1.8 0.000204999 1.8 0.000205 1.8 0.000205999 1.8 0.000206 1.8 0.000206999 1.8 0.000207 1.8 0.000207999 1.8 0.000208 1.8 0.000208999 1.8 0.000209 1.8 0.000209999 1.8 0.00021 1.8 0.000210999 1.8 0.000211 1.8 0.000211999 1.8 0.000212 1.8 0.000212999 1.8 0.000213 1.8 0.000213999 1.8 0.000214 1.8 0.000214999 1.8 0.000215 1.8 0.000215999 1.8 0.000216 1.8 0.000216999 1.8 0.000217 1.8 0.000217999 1.8 0.000218 1.8 0.000218999 1.8 0.000219 1.8 0.000219999 1.8 0.00022 1.8 0.000220999 1.8 0.000221 1.8 0.000221999 1.8 0.000222 1.8 0.000222999 1.8 0.000223 1.8 0.000223999 1.8 0.000224 1.8 0.000224999 1.8 0.000225 1.8 0.000225999 1.8 0.000226 1.8 0.000226999 1.8 0.000227 1.8 0.000227999 1.8 0.000228 1.8 0.000228999 1.8 0.000229 1.8 0.000229999 1.8 0.00023 1.8 0.000230999 1.8 0.000231 1.8 0.000231999 1.8 0.000232 1.8 0.000232999 1.8 0.000233 1.8 0.000233999 1.8 0.000234 1.8 0.000234999 1.8 0.000235 1.8 0.000235999 1.8 0.000236 1.8 0.000236999 1.8 0.000237 1.8 0.000237999 1.8 0.000238 1.8 0.000238999 1.8 0.000239 1.8 0.000239999 1.8 0.00024 1.8 0.000240999 1.8 0.000241 1.8 0.000241999 1.8 0.000242 1.8 0.000242999 1.8 0.000243 1.8 0.000243999 1.8 0.000244 1.8 0.000244999 1.8 0.000245 1.8 0.000245999 1.8 0.000246 1.8 0.000246999 1.8 0.000247 1.8 0.000247999 1.8 0.000248 1.8 0.000248999 1.8 0.000249 1.8 0.000249999 1.8 0.00025 1.8 0.000250999 1.8 0.000251 1.8 0.000251999 1.8 0.000252 1.8 0.000252999 1.8 0.000253 1.8 0.000253999 1.8 0.000254 1.8 0.000254999 1.8 0.000255 1.8 0.000256 1.8)
V7 T[1] GND PWL(0 0 9.99e-07 0 1e-06 0 1.999e-06 0 2e-06 0 2.999e-06 0 3e-06 0 3.999e-06 0 4e-06 0 4.999e-06 0 5e-06 0 5.999e-06 0 6e-06 0 6.999e-06 0 7e-06 0 7.999e-06 0 8e-06 0 8.999e-06 0 9e-06 0 9.999e-06 0 1e-05 0 1.0999e-05 0 1.1e-05 0 1.1999e-05 0 1.2e-05 0 1.2999e-05 0 1.3e-05 0 1.3999e-05 0 1.4e-05 0 1.4999e-05 0 1.5e-05 0 1.5999e-05 0 1.6e-05 0 1.6999e-05 0 1.7e-05 0 1.7999e-05 0 1.8e-05 0 1.8999e-05 0 1.9e-05 0 1.9999e-05 0 2e-05 0 2.0999e-05 0 2.1e-05 0 2.1999e-05 0 2.2e-05 0 2.2999e-05 0 2.3e-05 0 2.3999e-05 0 2.4e-05 0 2.4999e-05 0 2.5e-05 0 2.5999e-05 0 2.6e-05 0 2.6999e-05 0 2.7e-05 0 2.7999e-05 0 2.8e-05 0 2.8999e-05 0 2.9e-05 0 2.9999e-05 0 3e-05 0 3.0999e-05 0 3.1e-05 0 3.1999e-05 0 3.2e-05 0 3.2999e-05 0 3.3e-05 0 3.3999e-05 0 3.4e-05 0 3.4999e-05 0 3.5e-05 0 3.5999e-05 0 3.6e-05 0 3.6999e-05 0 3.7e-05 0 3.7999e-05 0 3.8e-05 0 3.8999e-05 0 3.9e-05 0 3.9999e-05 0 4e-05 0 4.0999e-05 0 4.1e-05 0 4.1999e-05 0 4.2e-05 0 4.2999e-05 0 4.3e-05 0 4.3999e-05 0 4.4e-05 0 4.4999e-05 0 4.5e-05 0 4.5999e-05 0 4.6e-05 0 4.6999e-05 0 4.7e-05 0 4.7999e-05 0 4.8e-05 0 4.8999e-05 0 4.9e-05 0 4.9999e-05 0 5e-05 0 5.0999e-05 0 5.1e-05 0 5.1999e-05 0 5.2e-05 0 5.2999e-05 0 5.3e-05 0 5.3999e-05 0 5.4e-05 0 5.4999e-05 0 5.5e-05 0 5.5999e-05 0 5.6e-05 0 5.6999e-05 0 5.7e-05 0 5.7999e-05 0 5.8e-05 0 5.8999e-05 0 5.9e-05 0 5.9999e-05 0 6e-05 0 6.0999e-05 0 6.1e-05 0 6.1999e-05 0 6.2e-05 0 6.2999e-05 0 6.3e-05 0 6.3999e-05 0 6.4e-05 1.8 6.4999e-05 1.8 6.5e-05 1.8 6.5999e-05 1.8 6.6e-05 1.8 6.6999e-05 1.8 6.7e-05 1.8 6.7999e-05 1.8 6.8e-05 1.8 6.8999e-05 1.8 6.9e-05 1.8 6.9999e-05 1.8 7e-05 1.8 7.0999e-05 1.8 7.1e-05 1.8 7.1999e-05 1.8 7.2e-05 1.8 7.2999e-05 1.8 7.3e-05 1.8 7.3999e-05 1.8 7.4e-05 1.8 7.4999e-05 1.8 7.5e-05 1.8 7.5999e-05 1.8 7.6e-05 1.8 7.6999e-05 1.8 7.7e-05 1.8 7.7999e-05 1.8 7.8e-05 1.8 7.8999e-05 1.8 7.9e-05 1.8 7.9999e-05 1.8 8e-05 1.8 8.0999e-05 1.8 8.1e-05 1.8 8.1999e-05 1.8 8.2e-05 1.8 8.2999e-05 1.8 8.3e-05 1.8 8.3999e-05 1.8 8.4e-05 1.8 8.4999e-05 1.8 8.5e-05 1.8 8.5999e-05 1.8 8.6e-05 1.8 8.6999e-05 1.8 8.7e-05 1.8 8.7999e-05 1.8 8.8e-05 1.8 8.8999e-05 1.8 8.9e-05 1.8 8.9999e-05 1.8 9e-05 1.8 9.0999e-05 1.8 9.1e-05 1.8 9.1999e-05 1.8 9.2e-05 1.8 9.2999e-05 1.8 9.3e-05 1.8 9.3999e-05 1.8 9.4e-05 1.8 9.4999e-05 1.8 9.5e-05 1.8 9.5999e-05 1.8 9.6e-05 1.8 9.6999e-05 1.8 9.7e-05 1.8 9.7999e-05 1.8 9.8e-05 1.8 9.8999e-05 1.8 9.9e-05 1.8 9.9999e-05 1.8 0.0001 1.8 0.000100999 1.8 0.000101 1.8 0.000101999 1.8 0.000102 1.8 0.000102999 1.8 0.000103 1.8 0.000103999 1.8 0.000104 1.8 0.000104999 1.8 0.000105 1.8 0.000105999 1.8 0.000106 1.8 0.000106999 1.8 0.000107 1.8 0.000107999 1.8 0.000108 1.8 0.000108999 1.8 0.000109 1.8 0.000109999 1.8 0.00011 1.8 0.000110999 1.8 0.000111 1.8 0.000111999 1.8 0.000112 1.8 0.000112999 1.8 0.000113 1.8 0.000113999 1.8 0.000114 1.8 0.000114999 1.8 0.000115 1.8 0.000115999 1.8 0.000116 1.8 0.000116999 1.8 0.000117 1.8 0.000117999 1.8 0.000118 1.8 0.000118999 1.8 0.000119 1.8 0.000119999 1.8 0.00012 1.8 0.000120999 1.8 0.000121 1.8 0.000121999 1.8 0.000122 1.8 0.000122999 1.8 0.000123 1.8 0.000123999 1.8 0.000124 1.8 0.000124999 1.8 0.000125 1.8 0.000125999 1.8 0.000126 1.8 0.000126999 1.8 0.000127 1.8 0.000127999 1.8 0.000128 1.8 0.000128999 1.8 0.000129 1.8 0.000129999 1.8 0.00013 1.8 0.000130999 1.8 0.000131 1.8 0.000131999 1.8 0.000132 1.8 0.000132999 1.8 0.000133 1.8 0.000133999 1.8 0.000134 1.8 0.000134999 1.8 0.000135 1.8 0.000135999 1.8 0.000136 1.8 0.000136999 1.8 0.000137 1.8 0.000137999 1.8 0.000138 1.8 0.000138999 1.8 0.000139 1.8 0.000139999 1.8 0.00014 1.8 0.000140999 1.8 0.000141 1.8 0.000141999 1.8 0.000142 1.8 0.000142999 1.8 0.000143 1.8 0.000143999 1.8 0.000144 1.8 0.000144999 1.8 0.000145 1.8 0.000145999 1.8 0.000146 1.8 0.000146999 1.8 0.000147 1.8 0.000147999 1.8 0.000148 1.8 0.000148999 1.8 0.000149 1.8 0.000149999 1.8 0.00015 1.8 0.000150999 1.8 0.000151 1.8 0.000151999 1.8 0.000152 1.8 0.000152999 1.8 0.000153 1.8 0.000153999 1.8 0.000154 1.8 0.000154999 1.8 0.000155 1.8 0.000155999 1.8 0.000156 1.8 0.000156999 1.8 0.000157 1.8 0.000157999 1.8 0.000158 1.8 0.000158999 1.8 0.000159 1.8 0.000159999 1.8 0.00016 1.8 0.000160999 1.8 0.000161 1.8 0.000161999 1.8 0.000162 1.8 0.000162999 1.8 0.000163 1.8 0.000163999 1.8 0.000164 1.8 0.000164999 1.8 0.000165 1.8 0.000165999 1.8 0.000166 1.8 0.000166999 1.8 0.000167 1.8 0.000167999 1.8 0.000168 1.8 0.000168999 1.8 0.000169 1.8 0.000169999 1.8 0.00017 1.8 0.000170999 1.8 0.000171 1.8 0.000171999 1.8 0.000172 1.8 0.000172999 1.8 0.000173 1.8 0.000173999 1.8 0.000174 1.8 0.000174999 1.8 0.000175 1.8 0.000175999 1.8 0.000176 1.8 0.000176999 1.8 0.000177 1.8 0.000177999 1.8 0.000178 1.8 0.000178999 1.8 0.000179 1.8 0.000179999 1.8 0.00018 1.8 0.000180999 1.8 0.000181 1.8 0.000181999 1.8 0.000182 1.8 0.000182999 1.8 0.000183 1.8 0.000183999 1.8 0.000184 1.8 0.000184999 1.8 0.000185 1.8 0.000185999 1.8 0.000186 1.8 0.000186999 1.8 0.000187 1.8 0.000187999 1.8 0.000188 1.8 0.000188999 1.8 0.000189 1.8 0.000189999 1.8 0.00019 1.8 0.000190999 1.8 0.000191 1.8 0.000191999 1.8 0.000192 1.8 0.000192999 1.8 0.000193 1.8 0.000193999 1.8 0.000194 1.8 0.000194999 1.8 0.000195 1.8 0.000195999 1.8 0.000196 1.8 0.000196999 1.8 0.000197 1.8 0.000197999 1.8 0.000198 1.8 0.000198999 1.8 0.000199 1.8 0.000199999 1.8 0.0002 1.8 0.000200999 1.8 0.000201 1.8 0.000201999 1.8 0.000202 1.8 0.000202999 1.8 0.000203 1.8 0.000203999 1.8 0.000204 1.8 0.000204999 1.8 0.000205 1.8 0.000205999 1.8 0.000206 1.8 0.000206999 1.8 0.000207 1.8 0.000207999 1.8 0.000208 1.8 0.000208999 1.8 0.000209 1.8 0.000209999 1.8 0.00021 1.8 0.000210999 1.8 0.000211 1.8 0.000211999 1.8 0.000212 1.8 0.000212999 1.8 0.000213 1.8 0.000213999 1.8 0.000214 1.8 0.000214999 1.8 0.000215 1.8 0.000215999 1.8 0.000216 1.8 0.000216999 1.8 0.000217 1.8 0.000217999 1.8 0.000218 1.8 0.000218999 1.8 0.000219 1.8 0.000219999 1.8 0.00022 1.8 0.000220999 1.8 0.000221 1.8 0.000221999 1.8 0.000222 1.8 0.000222999 1.8 0.000223 1.8 0.000223999 1.8 0.000224 1.8 0.000224999 1.8 0.000225 1.8 0.000225999 1.8 0.000226 1.8 0.000226999 1.8 0.000227 1.8 0.000227999 1.8 0.000228 1.8 0.000228999 1.8 0.000229 1.8 0.000229999 1.8 0.00023 1.8 0.000230999 1.8 0.000231 1.8 0.000231999 1.8 0.000232 1.8 0.000232999 1.8 0.000233 1.8 0.000233999 1.8 0.000234 1.8 0.000234999 1.8 0.000235 1.8 0.000235999 1.8 0.000236 1.8 0.000236999 1.8 0.000237 1.8 0.000237999 1.8 0.000238 1.8 0.000238999 1.8 0.000239 1.8 0.000239999 1.8 0.00024 1.8 0.000240999 1.8 0.000241 1.8 0.000241999 1.8 0.000242 1.8 0.000242999 1.8 0.000243 1.8 0.000243999 1.8 0.000244 1.8 0.000244999 1.8 0.000245 1.8 0.000245999 1.8 0.000246 1.8 0.000246999 1.8 0.000247 1.8 0.000247999 1.8 0.000248 1.8 0.000248999 1.8 0.000249 1.8 0.000249999 1.8 0.00025 1.8 0.000250999 1.8 0.000251 1.8 0.000251999 1.8 0.000252 1.8 0.000252999 1.8 0.000253 1.8 0.000253999 1.8 0.000254 1.8 0.000254999 1.8 0.000255 1.8 0.000256 1.8)
V8 T[2] GND PWL(0 0 9.99e-07 0 1e-06 0 1.999e-06 0 2e-06 0 2.999e-06 0 3e-06 0 3.999e-06 0 4e-06 0 4.999e-06 0 5e-06 0 5.999e-06 0 6e-06 0 6.999e-06 0 7e-06 0 7.999e-06 0 8e-06 0 8.999e-06 0 9e-06 0 9.999e-06 0 1e-05 0 1.0999e-05 0 1.1e-05 0 1.1999e-05 0 1.2e-05 0 1.2999e-05 0 1.3e-05 0 1.3999e-05 0 1.4e-05 0 1.4999e-05 0 1.5e-05 0 1.5999e-05 0 1.6e-05 0 1.6999e-05 0 1.7e-05 0 1.7999e-05 0 1.8e-05 0 1.8999e-05 0 1.9e-05 0 1.9999e-05 0 2e-05 0 2.0999e-05 0 2.1e-05 0 2.1999e-05 0 2.2e-05 0 2.2999e-05 0 2.3e-05 0 2.3999e-05 0 2.4e-05 0 2.4999e-05 0 2.5e-05 0 2.5999e-05 0 2.6e-05 0 2.6999e-05 0 2.7e-05 0 2.7999e-05 0 2.8e-05 0 2.8999e-05 0 2.9e-05 0 2.9999e-05 0 3e-05 0 3.0999e-05 0 3.1e-05 0 3.1999e-05 0 3.2e-05 0 3.2999e-05 0 3.3e-05 0 3.3999e-05 0 3.4e-05 0 3.4999e-05 0 3.5e-05 0 3.5999e-05 0 3.6e-05 0 3.6999e-05 0 3.7e-05 0 3.7999e-05 0 3.8e-05 0 3.8999e-05 0 3.9e-05 0 3.9999e-05 0 4e-05 0 4.0999e-05 0 4.1e-05 0 4.1999e-05 0 4.2e-05 0 4.2999e-05 0 4.3e-05 0 4.3999e-05 0 4.4e-05 0 4.4999e-05 0 4.5e-05 0 4.5999e-05 0 4.6e-05 0 4.6999e-05 0 4.7e-05 0 4.7999e-05 0 4.8e-05 0 4.8999e-05 0 4.9e-05 0 4.9999e-05 0 5e-05 0 5.0999e-05 0 5.1e-05 0 5.1999e-05 0 5.2e-05 0 5.2999e-05 0 5.3e-05 0 5.3999e-05 0 5.4e-05 0 5.4999e-05 0 5.5e-05 0 5.5999e-05 0 5.6e-05 0 5.6999e-05 0 5.7e-05 0 5.7999e-05 0 5.8e-05 0 5.8999e-05 0 5.9e-05 0 5.9999e-05 0 6e-05 0 6.0999e-05 0 6.1e-05 0 6.1999e-05 0 6.2e-05 0 6.2999e-05 0 6.3e-05 0 6.3999e-05 0 6.4e-05 0 6.4999e-05 0 6.5e-05 0 6.5999e-05 0 6.6e-05 0 6.6999e-05 0 6.7e-05 0 6.7999e-05 0 6.8e-05 0 6.8999e-05 0 6.9e-05 0 6.9999e-05 0 7e-05 0 7.0999e-05 0 7.1e-05 0 7.1999e-05 0 7.2e-05 0 7.2999e-05 0 7.3e-05 0 7.3999e-05 0 7.4e-05 0 7.4999e-05 0 7.5e-05 0 7.5999e-05 0 7.6e-05 0 7.6999e-05 0 7.7e-05 0 7.7999e-05 0 7.8e-05 0 7.8999e-05 0 7.9e-05 0 7.9999e-05 0 8e-05 0 8.0999e-05 0 8.1e-05 0 8.1999e-05 0 8.2e-05 0 8.2999e-05 0 8.3e-05 0 8.3999e-05 0 8.4e-05 0 8.4999e-05 0 8.5e-05 0 8.5999e-05 0 8.6e-05 0 8.6999e-05 0 8.7e-05 0 8.7999e-05 0 8.8e-05 0 8.8999e-05 0 8.9e-05 0 8.9999e-05 0 9e-05 0 9.0999e-05 0 9.1e-05 0 9.1999e-05 0 9.2e-05 0 9.2999e-05 0 9.3e-05 0 9.3999e-05 0 9.4e-05 0 9.4999e-05 0 9.5e-05 0 9.5999e-05 0 9.6e-05 1.8 9.6999e-05 1.8 9.7e-05 1.8 9.7999e-05 1.8 9.8e-05 1.8 9.8999e-05 1.8 9.9e-05 1.8 9.9999e-05 1.8 0.0001 1.8 0.000100999 1.8 0.000101 1.8 0.000101999 1.8 0.000102 1.8 0.000102999 1.8 0.000103 1.8 0.000103999 1.8 0.000104 1.8 0.000104999 1.8 0.000105 1.8 0.000105999 1.8 0.000106 1.8 0.000106999 1.8 0.000107 1.8 0.000107999 1.8 0.000108 1.8 0.000108999 1.8 0.000109 1.8 0.000109999 1.8 0.00011 1.8 0.000110999 1.8 0.000111 1.8 0.000111999 1.8 0.000112 1.8 0.000112999 1.8 0.000113 1.8 0.000113999 1.8 0.000114 1.8 0.000114999 1.8 0.000115 1.8 0.000115999 1.8 0.000116 1.8 0.000116999 1.8 0.000117 1.8 0.000117999 1.8 0.000118 1.8 0.000118999 1.8 0.000119 1.8 0.000119999 1.8 0.00012 1.8 0.000120999 1.8 0.000121 1.8 0.000121999 1.8 0.000122 1.8 0.000122999 1.8 0.000123 1.8 0.000123999 1.8 0.000124 1.8 0.000124999 1.8 0.000125 1.8 0.000125999 1.8 0.000126 1.8 0.000126999 1.8 0.000127 1.8 0.000127999 1.8 0.000128 1.8 0.000128999 1.8 0.000129 1.8 0.000129999 1.8 0.00013 1.8 0.000130999 1.8 0.000131 1.8 0.000131999 1.8 0.000132 1.8 0.000132999 1.8 0.000133 1.8 0.000133999 1.8 0.000134 1.8 0.000134999 1.8 0.000135 1.8 0.000135999 1.8 0.000136 1.8 0.000136999 1.8 0.000137 1.8 0.000137999 1.8 0.000138 1.8 0.000138999 1.8 0.000139 1.8 0.000139999 1.8 0.00014 1.8 0.000140999 1.8 0.000141 1.8 0.000141999 1.8 0.000142 1.8 0.000142999 1.8 0.000143 1.8 0.000143999 1.8 0.000144 1.8 0.000144999 1.8 0.000145 1.8 0.000145999 1.8 0.000146 1.8 0.000146999 1.8 0.000147 1.8 0.000147999 1.8 0.000148 1.8 0.000148999 1.8 0.000149 1.8 0.000149999 1.8 0.00015 1.8 0.000150999 1.8 0.000151 1.8 0.000151999 1.8 0.000152 1.8 0.000152999 1.8 0.000153 1.8 0.000153999 1.8 0.000154 1.8 0.000154999 1.8 0.000155 1.8 0.000155999 1.8 0.000156 1.8 0.000156999 1.8 0.000157 1.8 0.000157999 1.8 0.000158 1.8 0.000158999 1.8 0.000159 1.8 0.000159999 1.8 0.00016 1.8 0.000160999 1.8 0.000161 1.8 0.000161999 1.8 0.000162 1.8 0.000162999 1.8 0.000163 1.8 0.000163999 1.8 0.000164 1.8 0.000164999 1.8 0.000165 1.8 0.000165999 1.8 0.000166 1.8 0.000166999 1.8 0.000167 1.8 0.000167999 1.8 0.000168 1.8 0.000168999 1.8 0.000169 1.8 0.000169999 1.8 0.00017 1.8 0.000170999 1.8 0.000171 1.8 0.000171999 1.8 0.000172 1.8 0.000172999 1.8 0.000173 1.8 0.000173999 1.8 0.000174 1.8 0.000174999 1.8 0.000175 1.8 0.000175999 1.8 0.000176 1.8 0.000176999 1.8 0.000177 1.8 0.000177999 1.8 0.000178 1.8 0.000178999 1.8 0.000179 1.8 0.000179999 1.8 0.00018 1.8 0.000180999 1.8 0.000181 1.8 0.000181999 1.8 0.000182 1.8 0.000182999 1.8 0.000183 1.8 0.000183999 1.8 0.000184 1.8 0.000184999 1.8 0.000185 1.8 0.000185999 1.8 0.000186 1.8 0.000186999 1.8 0.000187 1.8 0.000187999 1.8 0.000188 1.8 0.000188999 1.8 0.000189 1.8 0.000189999 1.8 0.00019 1.8 0.000190999 1.8 0.000191 1.8 0.000191999 1.8 0.000192 1.8 0.000192999 1.8 0.000193 1.8 0.000193999 1.8 0.000194 1.8 0.000194999 1.8 0.000195 1.8 0.000195999 1.8 0.000196 1.8 0.000196999 1.8 0.000197 1.8 0.000197999 1.8 0.000198 1.8 0.000198999 1.8 0.000199 1.8 0.000199999 1.8 0.0002 1.8 0.000200999 1.8 0.000201 1.8 0.000201999 1.8 0.000202 1.8 0.000202999 1.8 0.000203 1.8 0.000203999 1.8 0.000204 1.8 0.000204999 1.8 0.000205 1.8 0.000205999 1.8 0.000206 1.8 0.000206999 1.8 0.000207 1.8 0.000207999 1.8 0.000208 1.8 0.000208999 1.8 0.000209 1.8 0.000209999 1.8 0.00021 1.8 0.000210999 1.8 0.000211 1.8 0.000211999 1.8 0.000212 1.8 0.000212999 1.8 0.000213 1.8 0.000213999 1.8 0.000214 1.8 0.000214999 1.8 0.000215 1.8 0.000215999 1.8 0.000216 1.8 0.000216999 1.8 0.000217 1.8 0.000217999 1.8 0.000218 1.8 0.000218999 1.8 0.000219 1.8 0.000219999 1.8 0.00022 1.8 0.000220999 1.8 0.000221 1.8 0.000221999 1.8 0.000222 1.8 0.000222999 1.8 0.000223 1.8 0.000223999 1.8 0.000224 1.8 0.000224999 1.8 0.000225 1.8 0.000225999 1.8 0.000226 1.8 0.000226999 1.8 0.000227 1.8 0.000227999 1.8 0.000228 1.8 0.000228999 1.8 0.000229 1.8 0.000229999 1.8 0.00023 1.8 0.000230999 1.8 0.000231 1.8 0.000231999 1.8 0.000232 1.8 0.000232999 1.8 0.000233 1.8 0.000233999 1.8 0.000234 1.8 0.000234999 1.8 0.000235 1.8 0.000235999 1.8 0.000236 1.8 0.000236999 1.8 0.000237 1.8 0.000237999 1.8 0.000238 1.8 0.000238999 1.8 0.000239 1.8 0.000239999 1.8 0.00024 1.8 0.000240999 1.8 0.000241 1.8 0.000241999 1.8 0.000242 1.8 0.000242999 1.8 0.000243 1.8 0.000243999 1.8 0.000244 1.8 0.000244999 1.8 0.000245 1.8 0.000245999 1.8 0.000246 1.8 0.000246999 1.8 0.000247 1.8 0.000247999 1.8 0.000248 1.8 0.000248999 1.8 0.000249 1.8 0.000249999 1.8 0.00025 1.8 0.000250999 1.8 0.000251 1.8 0.000251999 1.8 0.000252 1.8 0.000252999 1.8 0.000253 1.8 0.000253999 1.8 0.000254 1.8 0.000254999 1.8 0.000255 1.8 0.000256 1.8)
V9 T[3] GND PWL(0 0 9.99e-07 0 1e-06 0 1.999e-06 0 2e-06 0 2.999e-06 0 3e-06 0 3.999e-06 0 4e-06 0 4.999e-06 0 5e-06 0 5.999e-06 0 6e-06 0 6.999e-06 0 7e-06 0 7.999e-06 0 8e-06 0 8.999e-06 0 9e-06 0 9.999e-06 0 1e-05 0 1.0999e-05 0 1.1e-05 0 1.1999e-05 0 1.2e-05 0 1.2999e-05 0 1.3e-05 0 1.3999e-05 0 1.4e-05 0 1.4999e-05 0 1.5e-05 0 1.5999e-05 0 1.6e-05 0 1.6999e-05 0 1.7e-05 0 1.7999e-05 0 1.8e-05 0 1.8999e-05 0 1.9e-05 0 1.9999e-05 0 2e-05 0 2.0999e-05 0 2.1e-05 0 2.1999e-05 0 2.2e-05 0 2.2999e-05 0 2.3e-05 0 2.3999e-05 0 2.4e-05 0 2.4999e-05 0 2.5e-05 0 2.5999e-05 0 2.6e-05 0 2.6999e-05 0 2.7e-05 0 2.7999e-05 0 2.8e-05 0 2.8999e-05 0 2.9e-05 0 2.9999e-05 0 3e-05 0 3.0999e-05 0 3.1e-05 0 3.1999e-05 0 3.2e-05 0 3.2999e-05 0 3.3e-05 0 3.3999e-05 0 3.4e-05 0 3.4999e-05 0 3.5e-05 0 3.5999e-05 0 3.6e-05 0 3.6999e-05 0 3.7e-05 0 3.7999e-05 0 3.8e-05 0 3.8999e-05 0 3.9e-05 0 3.9999e-05 0 4e-05 0 4.0999e-05 0 4.1e-05 0 4.1999e-05 0 4.2e-05 0 4.2999e-05 0 4.3e-05 0 4.3999e-05 0 4.4e-05 0 4.4999e-05 0 4.5e-05 0 4.5999e-05 0 4.6e-05 0 4.6999e-05 0 4.7e-05 0 4.7999e-05 0 4.8e-05 0 4.8999e-05 0 4.9e-05 0 4.9999e-05 0 5e-05 0 5.0999e-05 0 5.1e-05 0 5.1999e-05 0 5.2e-05 0 5.2999e-05 0 5.3e-05 0 5.3999e-05 0 5.4e-05 0 5.4999e-05 0 5.5e-05 0 5.5999e-05 0 5.6e-05 0 5.6999e-05 0 5.7e-05 0 5.7999e-05 0 5.8e-05 0 5.8999e-05 0 5.9e-05 0 5.9999e-05 0 6e-05 0 6.0999e-05 0 6.1e-05 0 6.1999e-05 0 6.2e-05 0 6.2999e-05 0 6.3e-05 0 6.3999e-05 0 6.4e-05 0 6.4999e-05 0 6.5e-05 0 6.5999e-05 0 6.6e-05 0 6.6999e-05 0 6.7e-05 0 6.7999e-05 0 6.8e-05 0 6.8999e-05 0 6.9e-05 0 6.9999e-05 0 7e-05 0 7.0999e-05 0 7.1e-05 0 7.1999e-05 0 7.2e-05 0 7.2999e-05 0 7.3e-05 0 7.3999e-05 0 7.4e-05 0 7.4999e-05 0 7.5e-05 0 7.5999e-05 0 7.6e-05 0 7.6999e-05 0 7.7e-05 0 7.7999e-05 0 7.8e-05 0 7.8999e-05 0 7.9e-05 0 7.9999e-05 0 8e-05 0 8.0999e-05 0 8.1e-05 0 8.1999e-05 0 8.2e-05 0 8.2999e-05 0 8.3e-05 0 8.3999e-05 0 8.4e-05 0 8.4999e-05 0 8.5e-05 0 8.5999e-05 0 8.6e-05 0 8.6999e-05 0 8.7e-05 0 8.7999e-05 0 8.8e-05 0 8.8999e-05 0 8.9e-05 0 8.9999e-05 0 9e-05 0 9.0999e-05 0 9.1e-05 0 9.1999e-05 0 9.2e-05 0 9.2999e-05 0 9.3e-05 0 9.3999e-05 0 9.4e-05 0 9.4999e-05 0 9.5e-05 0 9.5999e-05 0 9.6e-05 0 9.6999e-05 0 9.7e-05 0 9.7999e-05 0 9.8e-05 0 9.8999e-05 0 9.9e-05 0 9.9999e-05 0 0.0001 0 0.000100999 0 0.000101 0 0.000101999 0 0.000102 0 0.000102999 0 0.000103 0 0.000103999 0 0.000104 0 0.000104999 0 0.000105 0 0.000105999 0 0.000106 0 0.000106999 0 0.000107 0 0.000107999 0 0.000108 0 0.000108999 0 0.000109 0 0.000109999 0 0.00011 0 0.000110999 0 0.000111 0 0.000111999 0 0.000112 0 0.000112999 0 0.000113 0 0.000113999 0 0.000114 0 0.000114999 0 0.000115 0 0.000115999 0 0.000116 0 0.000116999 0 0.000117 0 0.000117999 0 0.000118 0 0.000118999 0 0.000119 0 0.000119999 0 0.00012 0 0.000120999 0 0.000121 0 0.000121999 0 0.000122 0 0.000122999 0 0.000123 0 0.000123999 0 0.000124 0 0.000124999 0 0.000125 0 0.000125999 0 0.000126 0 0.000126999 0 0.000127 0 0.000127999 0 0.000128 1.8 0.000128999 1.8 0.000129 1.8 0.000129999 1.8 0.00013 1.8 0.000130999 1.8 0.000131 1.8 0.000131999 1.8 0.000132 1.8 0.000132999 1.8 0.000133 1.8 0.000133999 1.8 0.000134 1.8 0.000134999 1.8 0.000135 1.8 0.000135999 1.8 0.000136 1.8 0.000136999 1.8 0.000137 1.8 0.000137999 1.8 0.000138 1.8 0.000138999 1.8 0.000139 1.8 0.000139999 1.8 0.00014 1.8 0.000140999 1.8 0.000141 1.8 0.000141999 1.8 0.000142 1.8 0.000142999 1.8 0.000143 1.8 0.000143999 1.8 0.000144 1.8 0.000144999 1.8 0.000145 1.8 0.000145999 1.8 0.000146 1.8 0.000146999 1.8 0.000147 1.8 0.000147999 1.8 0.000148 1.8 0.000148999 1.8 0.000149 1.8 0.000149999 1.8 0.00015 1.8 0.000150999 1.8 0.000151 1.8 0.000151999 1.8 0.000152 1.8 0.000152999 1.8 0.000153 1.8 0.000153999 1.8 0.000154 1.8 0.000154999 1.8 0.000155 1.8 0.000155999 1.8 0.000156 1.8 0.000156999 1.8 0.000157 1.8 0.000157999 1.8 0.000158 1.8 0.000158999 1.8 0.000159 1.8 0.000159999 1.8 0.00016 1.8 0.000160999 1.8 0.000161 1.8 0.000161999 1.8 0.000162 1.8 0.000162999 1.8 0.000163 1.8 0.000163999 1.8 0.000164 1.8 0.000164999 1.8 0.000165 1.8 0.000165999 1.8 0.000166 1.8 0.000166999 1.8 0.000167 1.8 0.000167999 1.8 0.000168 1.8 0.000168999 1.8 0.000169 1.8 0.000169999 1.8 0.00017 1.8 0.000170999 1.8 0.000171 1.8 0.000171999 1.8 0.000172 1.8 0.000172999 1.8 0.000173 1.8 0.000173999 1.8 0.000174 1.8 0.000174999 1.8 0.000175 1.8 0.000175999 1.8 0.000176 1.8 0.000176999 1.8 0.000177 1.8 0.000177999 1.8 0.000178 1.8 0.000178999 1.8 0.000179 1.8 0.000179999 1.8 0.00018 1.8 0.000180999 1.8 0.000181 1.8 0.000181999 1.8 0.000182 1.8 0.000182999 1.8 0.000183 1.8 0.000183999 1.8 0.000184 1.8 0.000184999 1.8 0.000185 1.8 0.000185999 1.8 0.000186 1.8 0.000186999 1.8 0.000187 1.8 0.000187999 1.8 0.000188 1.8 0.000188999 1.8 0.000189 1.8 0.000189999 1.8 0.00019 1.8 0.000190999 1.8 0.000191 1.8 0.000191999 1.8 0.000192 1.8 0.000192999 1.8 0.000193 1.8 0.000193999 1.8 0.000194 1.8 0.000194999 1.8 0.000195 1.8 0.000195999 1.8 0.000196 1.8 0.000196999 1.8 0.000197 1.8 0.000197999 1.8 0.000198 1.8 0.000198999 1.8 0.000199 1.8 0.000199999 1.8 0.0002 1.8 0.000200999 1.8 0.000201 1.8 0.000201999 1.8 0.000202 1.8 0.000202999 1.8 0.000203 1.8 0.000203999 1.8 0.000204 1.8 0.000204999 1.8 0.000205 1.8 0.000205999 1.8 0.000206 1.8 0.000206999 1.8 0.000207 1.8 0.000207999 1.8 0.000208 1.8 0.000208999 1.8 0.000209 1.8 0.000209999 1.8 0.00021 1.8 0.000210999 1.8 0.000211 1.8 0.000211999 1.8 0.000212 1.8 0.000212999 1.8 0.000213 1.8 0.000213999 1.8 0.000214 1.8 0.000214999 1.8 0.000215 1.8 0.000215999 1.8 0.000216 1.8 0.000216999 1.8 0.000217 1.8 0.000217999 1.8 0.000218 1.8 0.000218999 1.8 0.000219 1.8 0.000219999 1.8 0.00022 1.8 0.000220999 1.8 0.000221 1.8 0.000221999 1.8 0.000222 1.8 0.000222999 1.8 0.000223 1.8 0.000223999 1.8 0.000224 1.8 0.000224999 1.8 0.000225 1.8 0.000225999 1.8 0.000226 1.8 0.000226999 1.8 0.000227 1.8 0.000227999 1.8 0.000228 1.8 0.000228999 1.8 0.000229 1.8 0.000229999 1.8 0.00023 1.8 0.000230999 1.8 0.000231 1.8 0.000231999 1.8 0.000232 1.8 0.000232999 1.8 0.000233 1.8 0.000233999 1.8 0.000234 1.8 0.000234999 1.8 0.000235 1.8 0.000235999 1.8 0.000236 1.8 0.000236999 1.8 0.000237 1.8 0.000237999 1.8 0.000238 1.8 0.000238999 1.8 0.000239 1.8 0.000239999 1.8 0.00024 1.8 0.000240999 1.8 0.000241 1.8 0.000241999 1.8 0.000242 1.8 0.000242999 1.8 0.000243 1.8 0.000243999 1.8 0.000244 1.8 0.000244999 1.8 0.000245 1.8 0.000245999 1.8 0.000246 1.8 0.000246999 1.8 0.000247 1.8 0.000247999 1.8 0.000248 1.8 0.000248999 1.8 0.000249 1.8 0.000249999 1.8 0.00025 1.8 0.000250999 1.8 0.000251 1.8 0.000251999 1.8 0.000252 1.8 0.000252999 1.8 0.000253 1.8 0.000253999 1.8 0.000254 1.8 0.000254999 1.8 0.000255 1.8 0.000256 1.8)
V10 T[4] GND PWL(0 0 9.99e-07 0 1e-06 0 1.999e-06 0 2e-06 0 2.999e-06 0 3e-06 0 3.999e-06 0 4e-06 0 4.999e-06 0 5e-06 0 5.999e-06 0 6e-06 0 6.999e-06 0 7e-06 0 7.999e-06 0 8e-06 0 8.999e-06 0 9e-06 0 9.999e-06 0 1e-05 0 1.0999e-05 0 1.1e-05 0 1.1999e-05 0 1.2e-05 0 1.2999e-05 0 1.3e-05 0 1.3999e-05 0 1.4e-05 0 1.4999e-05 0 1.5e-05 0 1.5999e-05 0 1.6e-05 0 1.6999e-05 0 1.7e-05 0 1.7999e-05 0 1.8e-05 0 1.8999e-05 0 1.9e-05 0 1.9999e-05 0 2e-05 0 2.0999e-05 0 2.1e-05 0 2.1999e-05 0 2.2e-05 0 2.2999e-05 0 2.3e-05 0 2.3999e-05 0 2.4e-05 0 2.4999e-05 0 2.5e-05 0 2.5999e-05 0 2.6e-05 0 2.6999e-05 0 2.7e-05 0 2.7999e-05 0 2.8e-05 0 2.8999e-05 0 2.9e-05 0 2.9999e-05 0 3e-05 0 3.0999e-05 0 3.1e-05 0 3.1999e-05 0 3.2e-05 0 3.2999e-05 0 3.3e-05 0 3.3999e-05 0 3.4e-05 0 3.4999e-05 0 3.5e-05 0 3.5999e-05 0 3.6e-05 0 3.6999e-05 0 3.7e-05 0 3.7999e-05 0 3.8e-05 0 3.8999e-05 0 3.9e-05 0 3.9999e-05 0 4e-05 0 4.0999e-05 0 4.1e-05 0 4.1999e-05 0 4.2e-05 0 4.2999e-05 0 4.3e-05 0 4.3999e-05 0 4.4e-05 0 4.4999e-05 0 4.5e-05 0 4.5999e-05 0 4.6e-05 0 4.6999e-05 0 4.7e-05 0 4.7999e-05 0 4.8e-05 0 4.8999e-05 0 4.9e-05 0 4.9999e-05 0 5e-05 0 5.0999e-05 0 5.1e-05 0 5.1999e-05 0 5.2e-05 0 5.2999e-05 0 5.3e-05 0 5.3999e-05 0 5.4e-05 0 5.4999e-05 0 5.5e-05 0 5.5999e-05 0 5.6e-05 0 5.6999e-05 0 5.7e-05 0 5.7999e-05 0 5.8e-05 0 5.8999e-05 0 5.9e-05 0 5.9999e-05 0 6e-05 0 6.0999e-05 0 6.1e-05 0 6.1999e-05 0 6.2e-05 0 6.2999e-05 0 6.3e-05 0 6.3999e-05 0 6.4e-05 0 6.4999e-05 0 6.5e-05 0 6.5999e-05 0 6.6e-05 0 6.6999e-05 0 6.7e-05 0 6.7999e-05 0 6.8e-05 0 6.8999e-05 0 6.9e-05 0 6.9999e-05 0 7e-05 0 7.0999e-05 0 7.1e-05 0 7.1999e-05 0 7.2e-05 0 7.2999e-05 0 7.3e-05 0 7.3999e-05 0 7.4e-05 0 7.4999e-05 0 7.5e-05 0 7.5999e-05 0 7.6e-05 0 7.6999e-05 0 7.7e-05 0 7.7999e-05 0 7.8e-05 0 7.8999e-05 0 7.9e-05 0 7.9999e-05 0 8e-05 0 8.0999e-05 0 8.1e-05 0 8.1999e-05 0 8.2e-05 0 8.2999e-05 0 8.3e-05 0 8.3999e-05 0 8.4e-05 0 8.4999e-05 0 8.5e-05 0 8.5999e-05 0 8.6e-05 0 8.6999e-05 0 8.7e-05 0 8.7999e-05 0 8.8e-05 0 8.8999e-05 0 8.9e-05 0 8.9999e-05 0 9e-05 0 9.0999e-05 0 9.1e-05 0 9.1999e-05 0 9.2e-05 0 9.2999e-05 0 9.3e-05 0 9.3999e-05 0 9.4e-05 0 9.4999e-05 0 9.5e-05 0 9.5999e-05 0 9.6e-05 0 9.6999e-05 0 9.7e-05 0 9.7999e-05 0 9.8e-05 0 9.8999e-05 0 9.9e-05 0 9.9999e-05 0 0.0001 0 0.000100999 0 0.000101 0 0.000101999 0 0.000102 0 0.000102999 0 0.000103 0 0.000103999 0 0.000104 0 0.000104999 0 0.000105 0 0.000105999 0 0.000106 0 0.000106999 0 0.000107 0 0.000107999 0 0.000108 0 0.000108999 0 0.000109 0 0.000109999 0 0.00011 0 0.000110999 0 0.000111 0 0.000111999 0 0.000112 0 0.000112999 0 0.000113 0 0.000113999 0 0.000114 0 0.000114999 0 0.000115 0 0.000115999 0 0.000116 0 0.000116999 0 0.000117 0 0.000117999 0 0.000118 0 0.000118999 0 0.000119 0 0.000119999 0 0.00012 0 0.000120999 0 0.000121 0 0.000121999 0 0.000122 0 0.000122999 0 0.000123 0 0.000123999 0 0.000124 0 0.000124999 0 0.000125 0 0.000125999 0 0.000126 0 0.000126999 0 0.000127 0 0.000127999 0 0.000128 0 0.000128999 0 0.000129 0 0.000129999 0 0.00013 0 0.000130999 0 0.000131 0 0.000131999 0 0.000132 0 0.000132999 0 0.000133 0 0.000133999 0 0.000134 0 0.000134999 0 0.000135 0 0.000135999 0 0.000136 0 0.000136999 0 0.000137 0 0.000137999 0 0.000138 0 0.000138999 0 0.000139 0 0.000139999 0 0.00014 0 0.000140999 0 0.000141 0 0.000141999 0 0.000142 0 0.000142999 0 0.000143 0 0.000143999 0 0.000144 0 0.000144999 0 0.000145 0 0.000145999 0 0.000146 0 0.000146999 0 0.000147 0 0.000147999 0 0.000148 0 0.000148999 0 0.000149 0 0.000149999 0 0.00015 0 0.000150999 0 0.000151 0 0.000151999 0 0.000152 0 0.000152999 0 0.000153 0 0.000153999 0 0.000154 0 0.000154999 0 0.000155 0 0.000155999 0 0.000156 0 0.000156999 0 0.000157 0 0.000157999 0 0.000158 0 0.000158999 0 0.000159 0 0.000159999 0 0.00016 1.8 0.000160999 1.8 0.000161 1.8 0.000161999 1.8 0.000162 1.8 0.000162999 1.8 0.000163 1.8 0.000163999 1.8 0.000164 1.8 0.000164999 1.8 0.000165 1.8 0.000165999 1.8 0.000166 1.8 0.000166999 1.8 0.000167 1.8 0.000167999 1.8 0.000168 1.8 0.000168999 1.8 0.000169 1.8 0.000169999 1.8 0.00017 1.8 0.000170999 1.8 0.000171 1.8 0.000171999 1.8 0.000172 1.8 0.000172999 1.8 0.000173 1.8 0.000173999 1.8 0.000174 1.8 0.000174999 1.8 0.000175 1.8 0.000175999 1.8 0.000176 1.8 0.000176999 1.8 0.000177 1.8 0.000177999 1.8 0.000178 1.8 0.000178999 1.8 0.000179 1.8 0.000179999 1.8 0.00018 1.8 0.000180999 1.8 0.000181 1.8 0.000181999 1.8 0.000182 1.8 0.000182999 1.8 0.000183 1.8 0.000183999 1.8 0.000184 1.8 0.000184999 1.8 0.000185 1.8 0.000185999 1.8 0.000186 1.8 0.000186999 1.8 0.000187 1.8 0.000187999 1.8 0.000188 1.8 0.000188999 1.8 0.000189 1.8 0.000189999 1.8 0.00019 1.8 0.000190999 1.8 0.000191 1.8 0.000191999 1.8 0.000192 1.8 0.000192999 1.8 0.000193 1.8 0.000193999 1.8 0.000194 1.8 0.000194999 1.8 0.000195 1.8 0.000195999 1.8 0.000196 1.8 0.000196999 1.8 0.000197 1.8 0.000197999 1.8 0.000198 1.8 0.000198999 1.8 0.000199 1.8 0.000199999 1.8 0.0002 1.8 0.000200999 1.8 0.000201 1.8 0.000201999 1.8 0.000202 1.8 0.000202999 1.8 0.000203 1.8 0.000203999 1.8 0.000204 1.8 0.000204999 1.8 0.000205 1.8 0.000205999 1.8 0.000206 1.8 0.000206999 1.8 0.000207 1.8 0.000207999 1.8 0.000208 1.8 0.000208999 1.8 0.000209 1.8 0.000209999 1.8 0.00021 1.8 0.000210999 1.8 0.000211 1.8 0.000211999 1.8 0.000212 1.8 0.000212999 1.8 0.000213 1.8 0.000213999 1.8 0.000214 1.8 0.000214999 1.8 0.000215 1.8 0.000215999 1.8 0.000216 1.8 0.000216999 1.8 0.000217 1.8 0.000217999 1.8 0.000218 1.8 0.000218999 1.8 0.000219 1.8 0.000219999 1.8 0.00022 1.8 0.000220999 1.8 0.000221 1.8 0.000221999 1.8 0.000222 1.8 0.000222999 1.8 0.000223 1.8 0.000223999 1.8 0.000224 1.8 0.000224999 1.8 0.000225 1.8 0.000225999 1.8 0.000226 1.8 0.000226999 1.8 0.000227 1.8 0.000227999 1.8 0.000228 1.8 0.000228999 1.8 0.000229 1.8 0.000229999 1.8 0.00023 1.8 0.000230999 1.8 0.000231 1.8 0.000231999 1.8 0.000232 1.8 0.000232999 1.8 0.000233 1.8 0.000233999 1.8 0.000234 1.8 0.000234999 1.8 0.000235 1.8 0.000235999 1.8 0.000236 1.8 0.000236999 1.8 0.000237 1.8 0.000237999 1.8 0.000238 1.8 0.000238999 1.8 0.000239 1.8 0.000239999 1.8 0.00024 1.8 0.000240999 1.8 0.000241 1.8 0.000241999 1.8 0.000242 1.8 0.000242999 1.8 0.000243 1.8 0.000243999 1.8 0.000244 1.8 0.000244999 1.8 0.000245 1.8 0.000245999 1.8 0.000246 1.8 0.000246999 1.8 0.000247 1.8 0.000247999 1.8 0.000248 1.8 0.000248999 1.8 0.000249 1.8 0.000249999 1.8 0.00025 1.8 0.000250999 1.8 0.000251 1.8 0.000251999 1.8 0.000252 1.8 0.000252999 1.8 0.000253 1.8 0.000253999 1.8 0.000254 1.8 0.000254999 1.8 0.000255 1.8 0.000256 1.8)
V11 T[5] GND PWL(0 0 9.99e-07 0 1e-06 0 1.999e-06 0 2e-06 0 2.999e-06 0 3e-06 0 3.999e-06 0 4e-06 0 4.999e-06 0 5e-06 0 5.999e-06 0 6e-06 0 6.999e-06 0 7e-06 0 7.999e-06 0 8e-06 0 8.999e-06 0 9e-06 0 9.999e-06 0 1e-05 0 1.0999e-05 0 1.1e-05 0 1.1999e-05 0 1.2e-05 0 1.2999e-05 0 1.3e-05 0 1.3999e-05 0 1.4e-05 0 1.4999e-05 0 1.5e-05 0 1.5999e-05 0 1.6e-05 0 1.6999e-05 0 1.7e-05 0 1.7999e-05 0 1.8e-05 0 1.8999e-05 0 1.9e-05 0 1.9999e-05 0 2e-05 0 2.0999e-05 0 2.1e-05 0 2.1999e-05 0 2.2e-05 0 2.2999e-05 0 2.3e-05 0 2.3999e-05 0 2.4e-05 0 2.4999e-05 0 2.5e-05 0 2.5999e-05 0 2.6e-05 0 2.6999e-05 0 2.7e-05 0 2.7999e-05 0 2.8e-05 0 2.8999e-05 0 2.9e-05 0 2.9999e-05 0 3e-05 0 3.0999e-05 0 3.1e-05 0 3.1999e-05 0 3.2e-05 0 3.2999e-05 0 3.3e-05 0 3.3999e-05 0 3.4e-05 0 3.4999e-05 0 3.5e-05 0 3.5999e-05 0 3.6e-05 0 3.6999e-05 0 3.7e-05 0 3.7999e-05 0 3.8e-05 0 3.8999e-05 0 3.9e-05 0 3.9999e-05 0 4e-05 0 4.0999e-05 0 4.1e-05 0 4.1999e-05 0 4.2e-05 0 4.2999e-05 0 4.3e-05 0 4.3999e-05 0 4.4e-05 0 4.4999e-05 0 4.5e-05 0 4.5999e-05 0 4.6e-05 0 4.6999e-05 0 4.7e-05 0 4.7999e-05 0 4.8e-05 0 4.8999e-05 0 4.9e-05 0 4.9999e-05 0 5e-05 0 5.0999e-05 0 5.1e-05 0 5.1999e-05 0 5.2e-05 0 5.2999e-05 0 5.3e-05 0 5.3999e-05 0 5.4e-05 0 5.4999e-05 0 5.5e-05 0 5.5999e-05 0 5.6e-05 0 5.6999e-05 0 5.7e-05 0 5.7999e-05 0 5.8e-05 0 5.8999e-05 0 5.9e-05 0 5.9999e-05 0 6e-05 0 6.0999e-05 0 6.1e-05 0 6.1999e-05 0 6.2e-05 0 6.2999e-05 0 6.3e-05 0 6.3999e-05 0 6.4e-05 0 6.4999e-05 0 6.5e-05 0 6.5999e-05 0 6.6e-05 0 6.6999e-05 0 6.7e-05 0 6.7999e-05 0 6.8e-05 0 6.8999e-05 0 6.9e-05 0 6.9999e-05 0 7e-05 0 7.0999e-05 0 7.1e-05 0 7.1999e-05 0 7.2e-05 0 7.2999e-05 0 7.3e-05 0 7.3999e-05 0 7.4e-05 0 7.4999e-05 0 7.5e-05 0 7.5999e-05 0 7.6e-05 0 7.6999e-05 0 7.7e-05 0 7.7999e-05 0 7.8e-05 0 7.8999e-05 0 7.9e-05 0 7.9999e-05 0 8e-05 0 8.0999e-05 0 8.1e-05 0 8.1999e-05 0 8.2e-05 0 8.2999e-05 0 8.3e-05 0 8.3999e-05 0 8.4e-05 0 8.4999e-05 0 8.5e-05 0 8.5999e-05 0 8.6e-05 0 8.6999e-05 0 8.7e-05 0 8.7999e-05 0 8.8e-05 0 8.8999e-05 0 8.9e-05 0 8.9999e-05 0 9e-05 0 9.0999e-05 0 9.1e-05 0 9.1999e-05 0 9.2e-05 0 9.2999e-05 0 9.3e-05 0 9.3999e-05 0 9.4e-05 0 9.4999e-05 0 9.5e-05 0 9.5999e-05 0 9.6e-05 0 9.6999e-05 0 9.7e-05 0 9.7999e-05 0 9.8e-05 0 9.8999e-05 0 9.9e-05 0 9.9999e-05 0 0.0001 0 0.000100999 0 0.000101 0 0.000101999 0 0.000102 0 0.000102999 0 0.000103 0 0.000103999 0 0.000104 0 0.000104999 0 0.000105 0 0.000105999 0 0.000106 0 0.000106999 0 0.000107 0 0.000107999 0 0.000108 0 0.000108999 0 0.000109 0 0.000109999 0 0.00011 0 0.000110999 0 0.000111 0 0.000111999 0 0.000112 0 0.000112999 0 0.000113 0 0.000113999 0 0.000114 0 0.000114999 0 0.000115 0 0.000115999 0 0.000116 0 0.000116999 0 0.000117 0 0.000117999 0 0.000118 0 0.000118999 0 0.000119 0 0.000119999 0 0.00012 0 0.000120999 0 0.000121 0 0.000121999 0 0.000122 0 0.000122999 0 0.000123 0 0.000123999 0 0.000124 0 0.000124999 0 0.000125 0 0.000125999 0 0.000126 0 0.000126999 0 0.000127 0 0.000127999 0 0.000128 0 0.000128999 0 0.000129 0 0.000129999 0 0.00013 0 0.000130999 0 0.000131 0 0.000131999 0 0.000132 0 0.000132999 0 0.000133 0 0.000133999 0 0.000134 0 0.000134999 0 0.000135 0 0.000135999 0 0.000136 0 0.000136999 0 0.000137 0 0.000137999 0 0.000138 0 0.000138999 0 0.000139 0 0.000139999 0 0.00014 0 0.000140999 0 0.000141 0 0.000141999 0 0.000142 0 0.000142999 0 0.000143 0 0.000143999 0 0.000144 0 0.000144999 0 0.000145 0 0.000145999 0 0.000146 0 0.000146999 0 0.000147 0 0.000147999 0 0.000148 0 0.000148999 0 0.000149 0 0.000149999 0 0.00015 0 0.000150999 0 0.000151 0 0.000151999 0 0.000152 0 0.000152999 0 0.000153 0 0.000153999 0 0.000154 0 0.000154999 0 0.000155 0 0.000155999 0 0.000156 0 0.000156999 0 0.000157 0 0.000157999 0 0.000158 0 0.000158999 0 0.000159 0 0.000159999 0 0.00016 0 0.000160999 0 0.000161 0 0.000161999 0 0.000162 0 0.000162999 0 0.000163 0 0.000163999 0 0.000164 0 0.000164999 0 0.000165 0 0.000165999 0 0.000166 0 0.000166999 0 0.000167 0 0.000167999 0 0.000168 0 0.000168999 0 0.000169 0 0.000169999 0 0.00017 0 0.000170999 0 0.000171 0 0.000171999 0 0.000172 0 0.000172999 0 0.000173 0 0.000173999 0 0.000174 0 0.000174999 0 0.000175 0 0.000175999 0 0.000176 0 0.000176999 0 0.000177 0 0.000177999 0 0.000178 0 0.000178999 0 0.000179 0 0.000179999 0 0.00018 0 0.000180999 0 0.000181 0 0.000181999 0 0.000182 0 0.000182999 0 0.000183 0 0.000183999 0 0.000184 0 0.000184999 0 0.000185 0 0.000185999 0 0.000186 0 0.000186999 0 0.000187 0 0.000187999 0 0.000188 0 0.000188999 0 0.000189 0 0.000189999 0 0.00019 0 0.000190999 0 0.000191 0 0.000191999 0 0.000192 1.8 0.000192999 1.8 0.000193 1.8 0.000193999 1.8 0.000194 1.8 0.000194999 1.8 0.000195 1.8 0.000195999 1.8 0.000196 1.8 0.000196999 1.8 0.000197 1.8 0.000197999 1.8 0.000198 1.8 0.000198999 1.8 0.000199 1.8 0.000199999 1.8 0.0002 1.8 0.000200999 1.8 0.000201 1.8 0.000201999 1.8 0.000202 1.8 0.000202999 1.8 0.000203 1.8 0.000203999 1.8 0.000204 1.8 0.000204999 1.8 0.000205 1.8 0.000205999 1.8 0.000206 1.8 0.000206999 1.8 0.000207 1.8 0.000207999 1.8 0.000208 1.8 0.000208999 1.8 0.000209 1.8 0.000209999 1.8 0.00021 1.8 0.000210999 1.8 0.000211 1.8 0.000211999 1.8 0.000212 1.8 0.000212999 1.8 0.000213 1.8 0.000213999 1.8 0.000214 1.8 0.000214999 1.8 0.000215 1.8 0.000215999 1.8 0.000216 1.8 0.000216999 1.8 0.000217 1.8 0.000217999 1.8 0.000218 1.8 0.000218999 1.8 0.000219 1.8 0.000219999 1.8 0.00022 1.8 0.000220999 1.8 0.000221 1.8 0.000221999 1.8 0.000222 1.8 0.000222999 1.8 0.000223 1.8 0.000223999 1.8 0.000224 1.8 0.000224999 1.8 0.000225 1.8 0.000225999 1.8 0.000226 1.8 0.000226999 1.8 0.000227 1.8 0.000227999 1.8 0.000228 1.8 0.000228999 1.8 0.000229 1.8 0.000229999 1.8 0.00023 1.8 0.000230999 1.8 0.000231 1.8 0.000231999 1.8 0.000232 1.8 0.000232999 1.8 0.000233 1.8 0.000233999 1.8 0.000234 1.8 0.000234999 1.8 0.000235 1.8 0.000235999 1.8 0.000236 1.8 0.000236999 1.8 0.000237 1.8 0.000237999 1.8 0.000238 1.8 0.000238999 1.8 0.000239 1.8 0.000239999 1.8 0.00024 1.8 0.000240999 1.8 0.000241 1.8 0.000241999 1.8 0.000242 1.8 0.000242999 1.8 0.000243 1.8 0.000243999 1.8 0.000244 1.8 0.000244999 1.8 0.000245 1.8 0.000245999 1.8 0.000246 1.8 0.000246999 1.8 0.000247 1.8 0.000247999 1.8 0.000248 1.8 0.000248999 1.8 0.000249 1.8 0.000249999 1.8 0.00025 1.8 0.000250999 1.8 0.000251 1.8 0.000251999 1.8 0.000252 1.8 0.000252999 1.8 0.000253 1.8 0.000253999 1.8 0.000254 1.8 0.000254999 1.8 0.000255 1.8 0.000256 1.8)
V12 T[6] GND PWL(0 0 9.99e-07 0 1e-06 0 1.999e-06 0 2e-06 0 2.999e-06 0 3e-06 0 3.999e-06 0 4e-06 0 4.999e-06 0 5e-06 0 5.999e-06 0 6e-06 0 6.999e-06 0 7e-06 0 7.999e-06 0 8e-06 0 8.999e-06 0 9e-06 0 9.999e-06 0 1e-05 0 1.0999e-05 0 1.1e-05 0 1.1999e-05 0 1.2e-05 0 1.2999e-05 0 1.3e-05 0 1.3999e-05 0 1.4e-05 0 1.4999e-05 0 1.5e-05 0 1.5999e-05 0 1.6e-05 0 1.6999e-05 0 1.7e-05 0 1.7999e-05 0 1.8e-05 0 1.8999e-05 0 1.9e-05 0 1.9999e-05 0 2e-05 0 2.0999e-05 0 2.1e-05 0 2.1999e-05 0 2.2e-05 0 2.2999e-05 0 2.3e-05 0 2.3999e-05 0 2.4e-05 0 2.4999e-05 0 2.5e-05 0 2.5999e-05 0 2.6e-05 0 2.6999e-05 0 2.7e-05 0 2.7999e-05 0 2.8e-05 0 2.8999e-05 0 2.9e-05 0 2.9999e-05 0 3e-05 0 3.0999e-05 0 3.1e-05 0 3.1999e-05 0 3.2e-05 0 3.2999e-05 0 3.3e-05 0 3.3999e-05 0 3.4e-05 0 3.4999e-05 0 3.5e-05 0 3.5999e-05 0 3.6e-05 0 3.6999e-05 0 3.7e-05 0 3.7999e-05 0 3.8e-05 0 3.8999e-05 0 3.9e-05 0 3.9999e-05 0 4e-05 0 4.0999e-05 0 4.1e-05 0 4.1999e-05 0 4.2e-05 0 4.2999e-05 0 4.3e-05 0 4.3999e-05 0 4.4e-05 0 4.4999e-05 0 4.5e-05 0 4.5999e-05 0 4.6e-05 0 4.6999e-05 0 4.7e-05 0 4.7999e-05 0 4.8e-05 0 4.8999e-05 0 4.9e-05 0 4.9999e-05 0 5e-05 0 5.0999e-05 0 5.1e-05 0 5.1999e-05 0 5.2e-05 0 5.2999e-05 0 5.3e-05 0 5.3999e-05 0 5.4e-05 0 5.4999e-05 0 5.5e-05 0 5.5999e-05 0 5.6e-05 0 5.6999e-05 0 5.7e-05 0 5.7999e-05 0 5.8e-05 0 5.8999e-05 0 5.9e-05 0 5.9999e-05 0 6e-05 0 6.0999e-05 0 6.1e-05 0 6.1999e-05 0 6.2e-05 0 6.2999e-05 0 6.3e-05 0 6.3999e-05 0 6.4e-05 0 6.4999e-05 0 6.5e-05 0 6.5999e-05 0 6.6e-05 0 6.6999e-05 0 6.7e-05 0 6.7999e-05 0 6.8e-05 0 6.8999e-05 0 6.9e-05 0 6.9999e-05 0 7e-05 0 7.0999e-05 0 7.1e-05 0 7.1999e-05 0 7.2e-05 0 7.2999e-05 0 7.3e-05 0 7.3999e-05 0 7.4e-05 0 7.4999e-05 0 7.5e-05 0 7.5999e-05 0 7.6e-05 0 7.6999e-05 0 7.7e-05 0 7.7999e-05 0 7.8e-05 0 7.8999e-05 0 7.9e-05 0 7.9999e-05 0 8e-05 0 8.0999e-05 0 8.1e-05 0 8.1999e-05 0 8.2e-05 0 8.2999e-05 0 8.3e-05 0 8.3999e-05 0 8.4e-05 0 8.4999e-05 0 8.5e-05 0 8.5999e-05 0 8.6e-05 0 8.6999e-05 0 8.7e-05 0 8.7999e-05 0 8.8e-05 0 8.8999e-05 0 8.9e-05 0 8.9999e-05 0 9e-05 0 9.0999e-05 0 9.1e-05 0 9.1999e-05 0 9.2e-05 0 9.2999e-05 0 9.3e-05 0 9.3999e-05 0 9.4e-05 0 9.4999e-05 0 9.5e-05 0 9.5999e-05 0 9.6e-05 0 9.6999e-05 0 9.7e-05 0 9.7999e-05 0 9.8e-05 0 9.8999e-05 0 9.9e-05 0 9.9999e-05 0 0.0001 0 0.000100999 0 0.000101 0 0.000101999 0 0.000102 0 0.000102999 0 0.000103 0 0.000103999 0 0.000104 0 0.000104999 0 0.000105 0 0.000105999 0 0.000106 0 0.000106999 0 0.000107 0 0.000107999 0 0.000108 0 0.000108999 0 0.000109 0 0.000109999 0 0.00011 0 0.000110999 0 0.000111 0 0.000111999 0 0.000112 0 0.000112999 0 0.000113 0 0.000113999 0 0.000114 0 0.000114999 0 0.000115 0 0.000115999 0 0.000116 0 0.000116999 0 0.000117 0 0.000117999 0 0.000118 0 0.000118999 0 0.000119 0 0.000119999 0 0.00012 0 0.000120999 0 0.000121 0 0.000121999 0 0.000122 0 0.000122999 0 0.000123 0 0.000123999 0 0.000124 0 0.000124999 0 0.000125 0 0.000125999 0 0.000126 0 0.000126999 0 0.000127 0 0.000127999 0 0.000128 0 0.000128999 0 0.000129 0 0.000129999 0 0.00013 0 0.000130999 0 0.000131 0 0.000131999 0 0.000132 0 0.000132999 0 0.000133 0 0.000133999 0 0.000134 0 0.000134999 0 0.000135 0 0.000135999 0 0.000136 0 0.000136999 0 0.000137 0 0.000137999 0 0.000138 0 0.000138999 0 0.000139 0 0.000139999 0 0.00014 0 0.000140999 0 0.000141 0 0.000141999 0 0.000142 0 0.000142999 0 0.000143 0 0.000143999 0 0.000144 0 0.000144999 0 0.000145 0 0.000145999 0 0.000146 0 0.000146999 0 0.000147 0 0.000147999 0 0.000148 0 0.000148999 0 0.000149 0 0.000149999 0 0.00015 0 0.000150999 0 0.000151 0 0.000151999 0 0.000152 0 0.000152999 0 0.000153 0 0.000153999 0 0.000154 0 0.000154999 0 0.000155 0 0.000155999 0 0.000156 0 0.000156999 0 0.000157 0 0.000157999 0 0.000158 0 0.000158999 0 0.000159 0 0.000159999 0 0.00016 0 0.000160999 0 0.000161 0 0.000161999 0 0.000162 0 0.000162999 0 0.000163 0 0.000163999 0 0.000164 0 0.000164999 0 0.000165 0 0.000165999 0 0.000166 0 0.000166999 0 0.000167 0 0.000167999 0 0.000168 0 0.000168999 0 0.000169 0 0.000169999 0 0.00017 0 0.000170999 0 0.000171 0 0.000171999 0 0.000172 0 0.000172999 0 0.000173 0 0.000173999 0 0.000174 0 0.000174999 0 0.000175 0 0.000175999 0 0.000176 0 0.000176999 0 0.000177 0 0.000177999 0 0.000178 0 0.000178999 0 0.000179 0 0.000179999 0 0.00018 0 0.000180999 0 0.000181 0 0.000181999 0 0.000182 0 0.000182999 0 0.000183 0 0.000183999 0 0.000184 0 0.000184999 0 0.000185 0 0.000185999 0 0.000186 0 0.000186999 0 0.000187 0 0.000187999 0 0.000188 0 0.000188999 0 0.000189 0 0.000189999 0 0.00019 0 0.000190999 0 0.000191 0 0.000191999 0 0.000192 0 0.000192999 0 0.000193 0 0.000193999 0 0.000194 0 0.000194999 0 0.000195 0 0.000195999 0 0.000196 0 0.000196999 0 0.000197 0 0.000197999 0 0.000198 0 0.000198999 0 0.000199 0 0.000199999 0 0.0002 0 0.000200999 0 0.000201 0 0.000201999 0 0.000202 0 0.000202999 0 0.000203 0 0.000203999 0 0.000204 0 0.000204999 0 0.000205 0 0.000205999 0 0.000206 0 0.000206999 0 0.000207 0 0.000207999 0 0.000208 0 0.000208999 0 0.000209 0 0.000209999 0 0.00021 0 0.000210999 0 0.000211 0 0.000211999 0 0.000212 0 0.000212999 0 0.000213 0 0.000213999 0 0.000214 0 0.000214999 0 0.000215 0 0.000215999 0 0.000216 0 0.000216999 0 0.000217 0 0.000217999 0 0.000218 0 0.000218999 0 0.000219 0 0.000219999 0 0.00022 0 0.000220999 0 0.000221 0 0.000221999 0 0.000222 0 0.000222999 0 0.000223 0 0.000223999 0 0.000224 1.8 0.000224999 1.8 0.000225 1.8 0.000225999 1.8 0.000226 1.8 0.000226999 1.8 0.000227 1.8 0.000227999 1.8 0.000228 1.8 0.000228999 1.8 0.000229 1.8 0.000229999 1.8 0.00023 1.8 0.000230999 1.8 0.000231 1.8 0.000231999 1.8 0.000232 1.8 0.000232999 1.8 0.000233 1.8 0.000233999 1.8 0.000234 1.8 0.000234999 1.8 0.000235 1.8 0.000235999 1.8 0.000236 1.8 0.000236999 1.8 0.000237 1.8 0.000237999 1.8 0.000238 1.8 0.000238999 1.8 0.000239 1.8 0.000239999 1.8 0.00024 1.8 0.000240999 1.8 0.000241 1.8 0.000241999 1.8 0.000242 1.8 0.000242999 1.8 0.000243 1.8 0.000243999 1.8 0.000244 1.8 0.000244999 1.8 0.000245 1.8 0.000245999 1.8 0.000246 1.8 0.000246999 1.8 0.000247 1.8 0.000247999 1.8 0.000248 1.8 0.000248999 1.8 0.000249 1.8 0.000249999 1.8 0.00025 1.8 0.000250999 1.8 0.000251 1.8 0.000251999 1.8 0.000252 1.8 0.000252999 1.8 0.000253 1.8 0.000253999 1.8 0.000254 1.8 0.000254999 1.8 0.000255 1.8 0.000256 1.8)
