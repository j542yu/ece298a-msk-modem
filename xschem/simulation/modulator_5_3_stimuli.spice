* Generated from Cocotb VCD

* Signal: clk
Vclk clk 0 PWL(
+ 0.000000000000e+00 3.300000
+ 9.999000000000e-09 3.300000
+ 1.000000000000e-08 0.000000
+ 1.999900000000e-08 0.000000
+ 2.000000000000e-08 3.300000
+ 2.999900000000e-08 3.300000
+ 3.000000000000e-08 0.000000
+ 3.999900000000e-08 0.000000
+ 4.000000000000e-08 3.300000
+ 4.999900000000e-08 3.300000
+ 5.000000000000e-08 0.000000
+ 5.999900000000e-08 0.000000
+ 6.000000000000e-08 3.300000
+ 6.999900000000e-08 3.300000
+ 7.000000000000e-08 0.000000
+ 7.999900000000e-08 0.000000
+ 8.000000000000e-08 3.300000
+ 8.999900000000e-08 3.300000
+ 9.000000000000e-08 0.000000
+ 9.999900000000e-08 0.000000
+ 1.000000000000e-07 3.300000
+ 1.099990000000e-07 3.300000
+ 1.100000000000e-07 0.000000
+ 1.199990000000e-07 0.000000
+ 1.200000000000e-07 3.300000
+ 1.299990000000e-07 3.300000
+ 1.300000000000e-07 0.000000
+ 1.399990000000e-07 0.000000
+ 1.400000000000e-07 3.300000
+ 1.499990000000e-07 3.300000
+ 1.500000000000e-07 0.000000
+ 1.599990000000e-07 0.000000
+ 1.600000000000e-07 3.300000
+ 1.699990000000e-07 3.300000
+ 1.700000000000e-07 0.000000
+ 1.799990000000e-07 0.000000
+ 1.800000000000e-07 3.300000
+ 1.899990000000e-07 3.300000
+ 1.900000000000e-07 0.000000
+ 1.999990000000e-07 0.000000
+ 2.000000000000e-07 3.300000
+ 2.099990000000e-07 3.300000
+ 2.100000000000e-07 0.000000
+ 2.199990000000e-07 0.000000
+ 2.200000000000e-07 3.300000
+ 2.299990000000e-07 3.300000
+ 2.300000000000e-07 0.000000
+ 2.399990000000e-07 0.000000
+ 2.400000000000e-07 3.300000
+ 2.499990000000e-07 3.300000
+ 2.500000000000e-07 0.000000
+ 2.599990000000e-07 0.000000
+ 2.600000000000e-07 3.300000
+ 2.699990000000e-07 3.300000
+ 2.700000000000e-07 0.000000
+ 2.799990000000e-07 0.000000
+ 2.800000000000e-07 3.300000
+ 2.899990000000e-07 3.300000
+ 2.900000000000e-07 0.000000
+ 2.999990000000e-07 0.000000
+ 3.000000000000e-07 3.300000
+ 3.099990000000e-07 3.300000
+ 3.100000000000e-07 0.000000
+ 3.199990000000e-07 0.000000
+ 3.200000000000e-07 3.300000
+ 3.299990000000e-07 3.300000
+ 3.300000000000e-07 0.000000
+ 3.399990000000e-07 0.000000
+ 3.400000000000e-07 3.300000
+ 3.499990000000e-07 3.300000
+ 3.500000000000e-07 0.000000
+ 3.599990000000e-07 0.000000
+ 3.600000000000e-07 3.300000
+ 3.699990000000e-07 3.300000
+ 3.700000000000e-07 0.000000
+ 3.799990000000e-07 0.000000
+ 3.800000000000e-07 3.300000
+ 3.899990000000e-07 3.300000
+ 3.900000000000e-07 0.000000
+ 3.999990000000e-07 0.000000
+ 4.000000000000e-07 3.300000
+ 4.099990000000e-07 3.300000
+ 4.100000000000e-07 0.000000
+ 4.199990000000e-07 0.000000
+ 4.200000000000e-07 3.300000
+ 4.299990000000e-07 3.300000
+ 4.300000000000e-07 0.000000
+ 4.399990000000e-07 0.000000
+ 4.400000000000e-07 3.300000
+ 4.499990000000e-07 3.300000
+ 4.500000000000e-07 0.000000
+ 4.599990000000e-07 0.000000
+ 4.600000000000e-07 3.300000
+ 4.699990000000e-07 3.300000
+ 4.700000000000e-07 0.000000
+ 4.799990000000e-07 0.000000
+ 4.800000000000e-07 3.300000
+ 4.899990000000e-07 3.300000
+ 4.900000000000e-07 0.000000
+ 4.999990000000e-07 0.000000
+ 5.000000000000e-07 3.300000
+ 5.099990000000e-07 3.300000
+ 5.100000000000e-07 0.000000
+ 5.199990000000e-07 0.000000
+ 5.200000000000e-07 3.300000
+ 5.299990000000e-07 3.300000
+ 5.300000000000e-07 0.000000
+ 5.399990000000e-07 0.000000
+ 5.400000000000e-07 3.300000
+ 5.499990000000e-07 3.300000
+ 5.500000000000e-07 0.000000
+ 5.599990000000e-07 0.000000
+ 5.600000000000e-07 3.300000
+ 5.699990000000e-07 3.300000
+ 5.700000000000e-07 0.000000
+ 5.799990000000e-07 0.000000
+ 5.800000000000e-07 3.300000
+ 5.899990000000e-07 3.300000
+ 5.900000000000e-07 0.000000
+ 5.999990000000e-07 0.000000
+ 6.000000000000e-07 3.300000
+ 6.099990000000e-07 3.300000
+ 6.100000000000e-07 0.000000
+ 6.199990000000e-07 0.000000
+ 6.200000000000e-07 3.300000
+ 6.299990000000e-07 3.300000
+ 6.300000000000e-07 0.000000
+ 6.399990000000e-07 0.000000
+ 6.400000000000e-07 3.300000
+ 6.499990000000e-07 3.300000
+ 6.500000000000e-07 0.000000
+ 6.599990000000e-07 0.000000
+ 6.600000000000e-07 3.300000
+ 6.699990000000e-07 3.300000
+ 6.700000000000e-07 0.000000
+ 6.799990000000e-07 0.000000
+ 6.800000000000e-07 3.300000
+ 6.899990000000e-07 3.300000
+ 6.900000000000e-07 0.000000
+ 6.999990000000e-07 0.000000
+ 7.000000000000e-07 3.300000
+ 7.099990000000e-07 3.300000
+ 7.100000000000e-07 0.000000
+ 7.199990000000e-07 0.000000
+ 7.200000000000e-07 3.300000
+ 7.299990000000e-07 3.300000
+ 7.300000000000e-07 0.000000
+ 7.399990000000e-07 0.000000
+ 7.400000000000e-07 3.300000
+ 7.499990000000e-07 3.300000
+ 7.500000000000e-07 0.000000
+ 7.599990000000e-07 0.000000
+ 7.600000000000e-07 3.300000
+ 7.699990000000e-07 3.300000
+ 7.700000000000e-07 0.000000
+ 7.799990000000e-07 0.000000
+ 7.800000000000e-07 3.300000
+ 7.899990000000e-07 3.300000
+ 7.900000000000e-07 0.000000
+ 7.999990000000e-07 0.000000
+ 8.000000000000e-07 3.300000
+ 8.099990000000e-07 3.300000
+ 8.100000000000e-07 0.000000
+ 8.199990000000e-07 0.000000
+ 8.200000000000e-07 3.300000
+ 8.299990000000e-07 3.300000
+ 8.300000000000e-07 0.000000
+ 8.399990000000e-07 0.000000
+ 8.400000000000e-07 3.300000
+ 8.499990000000e-07 3.300000
+ 8.500000000000e-07 0.000000
+ 8.599990000000e-07 0.000000
+ 8.600000000000e-07 3.300000
+ 8.699990000000e-07 3.300000
+ 8.700000000000e-07 0.000000
+ 8.799990000000e-07 0.000000
+ 8.800000000000e-07 3.300000
+ 8.899990000000e-07 3.300000
+ 8.900000000000e-07 0.000000
+ 8.999990000000e-07 0.000000
+ 9.000000000000e-07 3.300000
+ 9.099990000000e-07 3.300000
+ 9.100000000000e-07 0.000000
+ 9.199990000000e-07 0.000000
+ 9.200000000000e-07 3.300000
+ 9.299990000000e-07 3.300000
+ 9.300000000000e-07 0.000000
+ 9.399990000000e-07 0.000000
+ 9.400000000000e-07 3.300000
+ 9.499990000000e-07 3.300000
+ 9.500000000000e-07 0.000000
+ 9.599990000000e-07 0.000000
+ 9.600000000000e-07 3.300000
+ 9.699990000000e-07 3.300000
+ 9.700000000000e-07 0.000000
+ 9.799990000000e-07 0.000000
+ 9.800000000000e-07 3.300000
+ 9.899990000000e-07 3.300000
+ 9.900000000000e-07 0.000000
+ 9.999990000000e-07 0.000000
+ 1.000000000000e-06 3.300000
+ 1.009999000000e-06 3.300000
+ 1.010000000000e-06 0.000000
+ 1.019999000000e-06 0.000000
+ 1.020000000000e-06 3.300000
+ 1.029999000000e-06 3.300000
+ 1.030000000000e-06 0.000000
+ 1.039999000000e-06 0.000000
+ 1.040000000000e-06 3.300000
+ 1.049999000000e-06 3.300000
+ 1.050000000000e-06 0.000000
+ 1.059999000000e-06 0.000000
+ 1.060000000000e-06 3.300000
+ 1.069999000000e-06 3.300000
+ 1.070000000000e-06 0.000000
+ 1.079999000000e-06 0.000000
+ 1.080000000000e-06 3.300000
+ 1.089999000000e-06 3.300000
+ 1.090000000000e-06 0.000000
+ 1.099999000000e-06 0.000000
+ 1.100000000000e-06 3.300000
+ 1.109999000000e-06 3.300000
+ 1.110000000000e-06 0.000000
+ 1.119999000000e-06 0.000000
+ 1.120000000000e-06 3.300000
+ 1.129999000000e-06 3.300000
+ 1.130000000000e-06 0.000000
+ 1.139999000000e-06 0.000000
+ 1.140000000000e-06 3.300000
+ 1.149999000000e-06 3.300000
+ 1.150000000000e-06 0.000000
+ 1.159999000000e-06 0.000000
+ 1.160000000000e-06 3.300000
+ 1.169999000000e-06 3.300000
+ 1.170000000000e-06 0.000000
+ 1.179999000000e-06 0.000000
+ 1.180000000000e-06 3.300000
+ 1.189999000000e-06 3.300000
+ 1.190000000000e-06 0.000000
+ 1.199999000000e-06 0.000000
+ 1.200000000000e-06 3.300000
+ 1.209999000000e-06 3.300000
+ 1.210000000000e-06 0.000000
+ 1.219999000000e-06 0.000000
+ 1.220000000000e-06 3.300000
+ 1.229999000000e-06 3.300000
+ 1.230000000000e-06 0.000000
+ 1.239999000000e-06 0.000000
+ 1.240000000000e-06 3.300000
+ 1.249999000000e-06 3.300000
+ 1.250000000000e-06 0.000000
+ 1.259999000000e-06 0.000000
+ 1.260000000000e-06 3.300000
+ 1.269999000000e-06 3.300000
+ 1.270000000000e-06 0.000000
+ 1.279999000000e-06 0.000000
+ 1.280000000000e-06 3.300000
+ 1.289999000000e-06 3.300000
+ 1.290000000000e-06 0.000000
+ 1.299999000000e-06 0.000000
+ 1.300000000000e-06 3.300000
+ 1.309999000000e-06 3.300000
+ 1.310000000000e-06 0.000000
+ 1.319999000000e-06 0.000000
+ 1.320000000000e-06 3.300000
+ 1.329999000000e-06 3.300000
+ 1.330000000000e-06 0.000000
+ 1.339999000000e-06 0.000000
+ 1.340000000000e-06 3.300000
+ 1.349999000000e-06 3.300000
+ 1.350000000000e-06 0.000000
+ 1.359999000000e-06 0.000000
+ 1.360000000000e-06 3.300000
+ 1.369999000000e-06 3.300000
+ 1.370000000000e-06 0.000000
+ 1.379999000000e-06 0.000000
+ 1.380000000000e-06 3.300000
+ 1.389999000000e-06 3.300000
+ 1.390000000000e-06 0.000000
+ 1.399999000000e-06 0.000000
+ 1.400000000000e-06 3.300000
+ 1.409999000000e-06 3.300000
+ 1.410000000000e-06 0.000000
+ 1.419999000000e-06 0.000000
+ 1.420000000000e-06 3.300000
+ 1.429999000000e-06 3.300000
+ 1.430000000000e-06 0.000000
+ 1.439999000000e-06 0.000000
+ 1.440000000000e-06 3.300000
+ 1.449999000000e-06 3.300000
+ 1.450000000000e-06 0.000000
+ 1.459999000000e-06 0.000000
+ 1.460000000000e-06 3.300000
+ 1.469999000000e-06 3.300000
+ 1.470000000000e-06 0.000000
+ 1.479999000000e-06 0.000000
+ 1.480000000000e-06 3.300000
+ 1.489999000000e-06 3.300000
+ 1.490000000000e-06 0.000000
+ 1.499999000000e-06 0.000000
+ 1.500000000000e-06 3.300000
+ 1.509999000000e-06 3.300000
+ 1.510000000000e-06 0.000000
+ 1.519999000000e-06 0.000000
+ 1.520000000000e-06 3.300000
+ 1.529999000000e-06 3.300000
+ 1.530000000000e-06 0.000000
+ 1.539999000000e-06 0.000000
+ 1.540000000000e-06 3.300000
+ 1.549999000000e-06 3.300000
+ 1.550000000000e-06 0.000000
+ 1.559999000000e-06 0.000000
+ 1.560000000000e-06 3.300000
+ 1.569999000000e-06 3.300000
+ 1.570000000000e-06 0.000000
+ 1.579999000000e-06 0.000000
+ 1.580000000000e-06 3.300000
+ 1.589999000000e-06 3.300000
+ 1.590000000000e-06 0.000000
+ 1.599999000000e-06 0.000000
+ 1.600000000000e-06 3.300000
+ 1.609999000000e-06 3.300000
+ 1.610000000000e-06 0.000000
+ 1.619999000000e-06 0.000000
+ 1.620000000000e-06 3.300000
+ 1.629999000000e-06 3.300000
+ 1.630000000000e-06 0.000000
+ 1.639999000000e-06 0.000000
+ 1.640000000000e-06 3.300000
+ 1.649999000000e-06 3.300000
+ 1.650000000000e-06 0.000000
+ 1.659999000000e-06 0.000000
+ 1.660000000000e-06 3.300000
+ 1.669999000000e-06 3.300000
+ 1.670000000000e-06 0.000000
+ 1.679999000000e-06 0.000000
+ 1.680000000000e-06 3.300000
+ 1.689999000000e-06 3.300000
+ 1.690000000000e-06 0.000000
+ 1.699999000000e-06 0.000000
+ 1.700000000000e-06 3.300000
+ 1.709999000000e-06 3.300000
+ 1.710000000000e-06 0.000000
+ 1.719999000000e-06 0.000000
+ 1.720000000000e-06 3.300000
+ 1.729999000000e-06 3.300000
+ 1.730000000000e-06 0.000000
+ 1.739999000000e-06 0.000000
+ 1.740000000000e-06 3.300000
+ 1.749999000000e-06 3.300000
+ 1.750000000000e-06 0.000000
+ 1.759999000000e-06 0.000000
+ 1.760000000000e-06 3.300000
+ 1.769999000000e-06 3.300000
+ 1.770000000000e-06 0.000000
+ 1.779999000000e-06 0.000000
+ 1.780000000000e-06 3.300000
+ 1.789999000000e-06 3.300000
+ 1.790000000000e-06 0.000000
+ 1.799999000000e-06 0.000000
+ 1.800000000000e-06 3.300000
+ 1.809999000000e-06 3.300000
+ 1.810000000000e-06 0.000000
+ 1.819999000000e-06 0.000000
+ 1.820000000000e-06 3.300000
+ 1.829999000000e-06 3.300000
+ 1.830000000000e-06 0.000000
+ 1.839999000000e-06 0.000000
+ 1.840000000000e-06 3.300000
+ 1.849999000000e-06 3.300000
+ 1.850000000000e-06 0.000000
+ 1.859999000000e-06 0.000000
+ 1.860000000000e-06 3.300000
+ 1.869999000000e-06 3.300000
+ 1.870000000000e-06 0.000000
+ 1.879999000000e-06 0.000000
+ 1.880000000000e-06 3.300000
+ 1.889999000000e-06 3.300000
+ 1.890000000000e-06 0.000000
+ 1.899999000000e-06 0.000000
+ 1.900000000000e-06 3.300000
+ 1.909999000000e-06 3.300000
+ 1.910000000000e-06 0.000000
+ 1.919999000000e-06 0.000000
+ 1.920000000000e-06 3.300000
+ 1.929999000000e-06 3.300000
+ 1.930000000000e-06 0.000000
+ 1.939999000000e-06 0.000000
+ 1.940000000000e-06 3.300000
+ 1.949999000000e-06 3.300000
+ 1.950000000000e-06 0.000000
+ 1.959999000000e-06 0.000000
+ 1.960000000000e-06 3.300000
+ 1.969999000000e-06 3.300000
+ 1.970000000000e-06 0.000000
+ 1.979999000000e-06 0.000000
+ 1.980000000000e-06 3.300000
+ 1.989999000000e-06 3.300000
+ 1.990000000000e-06 0.000000
+ 1.999999000000e-06 0.000000
+ 2.000000000000e-06 3.300000
+ 2.009999000000e-06 3.300000
+ 2.010000000000e-06 0.000000
+ 2.019999000000e-06 0.000000
+ 2.020000000000e-06 3.300000
+ 2.029999000000e-06 3.300000
+ 2.030000000000e-06 0.000000
+ 2.039999000000e-06 0.000000
+ 2.040000000000e-06 3.300000
+ 2.049999000000e-06 3.300000
+ 2.050000000000e-06 0.000000
+ 2.059999000000e-06 0.000000
+ 2.060000000000e-06 3.300000
+ 2.069999000000e-06 3.300000
+ 2.070000000000e-06 0.000000
+ 2.079999000000e-06 0.000000
+ 2.080000000000e-06 3.300000
+ 2.089999000000e-06 3.300000
+ 2.090000000000e-06 0.000000
+ 2.099999000000e-06 0.000000
+ 2.100000000000e-06 3.300000
+ 2.109999000000e-06 3.300000
+ 2.110000000000e-06 0.000000
+ 2.119999000000e-06 0.000000
+ 2.120000000000e-06 3.300000
+ 2.129999000000e-06 3.300000
+ 2.130000000000e-06 0.000000
+ 2.139999000000e-06 0.000000
+ 2.140000000000e-06 3.300000
+ 2.149999000000e-06 3.300000
+ 2.150000000000e-06 0.000000
+ 2.159999000000e-06 0.000000
+ 2.160000000000e-06 3.300000
+ 2.169999000000e-06 3.300000
+ 2.170000000000e-06 0.000000
+ 2.179999000000e-06 0.000000
+ 2.180000000000e-06 3.300000
+ 2.189999000000e-06 3.300000
+ 2.190000000000e-06 0.000000
+ 2.199999000000e-06 0.000000
+ 2.200000000000e-06 3.300000
+ 2.209999000000e-06 3.300000
+ 2.210000000000e-06 0.000000
+ 2.219999000000e-06 0.000000
+ 2.220000000000e-06 3.300000
+ 2.229999000000e-06 3.300000
+ 2.230000000000e-06 0.000000
+ 2.239999000000e-06 0.000000
+ 2.240000000000e-06 3.300000
+ 2.249999000000e-06 3.300000
+ 2.250000000000e-06 0.000000
+ 2.259999000000e-06 0.000000
+ 2.260000000000e-06 3.300000
+ 2.269999000000e-06 3.300000
+ 2.270000000000e-06 0.000000
+ 2.279999000000e-06 0.000000
+ 2.280000000000e-06 3.300000
+ 2.289999000000e-06 3.300000
+ 2.290000000000e-06 0.000000
+ 2.299999000000e-06 0.000000
+ 2.300000000000e-06 3.300000
+ 2.309999000000e-06 3.300000
+ 2.310000000000e-06 0.000000
+ 2.319999000000e-06 0.000000
+ 2.320000000000e-06 3.300000
+ 2.329999000000e-06 3.300000
+ 2.330000000000e-06 0.000000
+ 2.339999000000e-06 0.000000
+ 2.340000000000e-06 3.300000
+ 2.349999000000e-06 3.300000
+ 2.350000000000e-06 0.000000
+ 2.359999000000e-06 0.000000
+ 2.360000000000e-06 3.300000
+ 2.369999000000e-06 3.300000
+ 2.370000000000e-06 0.000000
+ 2.379999000000e-06 0.000000
+ 2.380000000000e-06 3.300000
+ 2.389999000000e-06 3.300000
+ 2.390000000000e-06 0.000000
+ 2.399999000000e-06 0.000000
+ 2.400000000000e-06 3.300000
+ 2.409999000000e-06 3.300000
+ 2.410000000000e-06 0.000000
+ 2.419999000000e-06 0.000000
+ 2.420000000000e-06 3.300000
+ 2.429999000000e-06 3.300000
+ 2.430000000000e-06 0.000000
+ 2.439999000000e-06 0.000000
+ 2.440000000000e-06 3.300000
+ 2.449999000000e-06 3.300000
+ 2.450000000000e-06 0.000000
+ 2.459999000000e-06 0.000000
+ 2.460000000000e-06 3.300000
+ 2.469999000000e-06 3.300000
+ 2.470000000000e-06 0.000000
+ 2.479999000000e-06 0.000000
+ 2.480000000000e-06 3.300000
+ 2.489999000000e-06 3.300000
+ 2.490000000000e-06 0.000000
+ 2.499999000000e-06 0.000000
+ 2.500000000000e-06 3.300000
+ 2.509999000000e-06 3.300000
+ 2.510000000000e-06 0.000000
+ 2.519999000000e-06 0.000000
+ 2.520000000000e-06 3.300000
+ 2.529999000000e-06 3.300000
+ 2.530000000000e-06 0.000000
+ 2.539999000000e-06 0.000000
+ 2.540000000000e-06 3.300000
+ 2.549999000000e-06 3.300000
+ 2.550000000000e-06 0.000000
+ 2.559999000000e-06 0.000000
+ 2.560000000000e-06 3.300000
+ 2.569999000000e-06 3.300000
+ 2.570000000000e-06 0.000000
+ 2.579999000000e-06 0.000000
+ 2.580000000000e-06 3.300000
+ 2.589999000000e-06 3.300000
+ 2.590000000000e-06 0.000000
+ 2.599999000000e-06 0.000000
+ 2.600000000000e-06 3.300000
+ 2.609999000000e-06 3.300000
+ 2.610000000000e-06 0.000000
+ 2.619999000000e-06 0.000000
+ 2.620000000000e-06 3.300000
+ 2.629999000000e-06 3.300000
+ 2.630000000000e-06 0.000000
+ 2.639999000000e-06 0.000000
+ 2.640000000000e-06 3.300000
+ 2.649999000000e-06 3.300000
+ 2.650000000000e-06 0.000000
+ 2.659999000000e-06 0.000000
+ 2.660000000000e-06 3.300000
+ 2.669999000000e-06 3.300000
+ 2.670000000000e-06 0.000000
+ 2.679999000000e-06 0.000000
+ 2.680000000000e-06 3.300000
+ 2.689999000000e-06 3.300000
+ 2.690000000000e-06 0.000000
+ 2.699999000000e-06 0.000000
+ 2.700000000000e-06 3.300000
+ 2.709999000000e-06 3.300000
+ 2.710000000000e-06 0.000000
+ 2.719999000000e-06 0.000000
+ 2.720000000000e-06 3.300000
+ 2.729999000000e-06 3.300000
+ 2.730000000000e-06 0.000000
+ 2.739999000000e-06 0.000000
+ 2.740000000000e-06 3.300000
+ 2.749999000000e-06 3.300000
+ 2.750000000000e-06 0.000000
+ 2.759999000000e-06 0.000000
+ 2.760000000000e-06 3.300000
+ 2.769999000000e-06 3.300000
+ 2.770000000000e-06 0.000000
+ 2.779999000000e-06 0.000000
+ 2.780000000000e-06 3.300000
+ 2.789999000000e-06 3.300000
+ 2.790000000000e-06 0.000000
+ 2.799999000000e-06 0.000000
+ 2.800000000000e-06 3.300000
+ 2.809999000000e-06 3.300000
+ 2.810000000000e-06 0.000000
+ 2.819999000000e-06 0.000000
+ 2.820000000000e-06 3.300000
+ 2.829999000000e-06 3.300000
+ 2.830000000000e-06 0.000000
+ 2.839999000000e-06 0.000000
+ 2.840000000000e-06 3.300000
+ 2.849999000000e-06 3.300000
+ 2.850000000000e-06 0.000000
+ 2.859999000000e-06 0.000000
+ 2.860000000000e-06 3.300000
+ 2.869999000000e-06 3.300000
+ 2.870000000000e-06 0.000000
+ 2.879999000000e-06 0.000000
+ 2.880000000000e-06 3.300000
+ 2.889999000000e-06 3.300000
+ 2.890000000000e-06 0.000000
+ 2.899999000000e-06 0.000000
+ 2.900000000000e-06 3.300000
+ 2.909999000000e-06 3.300000
+ 2.910000000000e-06 0.000000
+ 2.919999000000e-06 0.000000
+ 2.920000000000e-06 3.300000
+ 2.929999000000e-06 3.300000
+ 2.930000000000e-06 0.000000
+ 2.939999000000e-06 0.000000
+ 2.940000000000e-06 3.300000
+ 2.949999000000e-06 3.300000
+ 2.950000000000e-06 0.000000
+ 2.959999000000e-06 0.000000
+ 2.960000000000e-06 3.300000
+ 2.969999000000e-06 3.300000
+ 2.970000000000e-06 0.000000
+ 2.979999000000e-06 0.000000
+ 2.980000000000e-06 3.300000
+ 2.989999000000e-06 3.300000
+ 2.990000000000e-06 0.000000
+ 2.999999000000e-06 0.000000
+ 3.000000000000e-06 3.300000
+ 3.009999000000e-06 3.300000
+ 3.010000000000e-06 0.000000
+ 3.019999000000e-06 0.000000
+ 3.020000000000e-06 3.300000
+ 3.029999000000e-06 3.300000
+ 3.030000000000e-06 0.000000
+ 3.039999000000e-06 0.000000
+ 3.040000000000e-06 3.300000
+ 3.049999000000e-06 3.300000
+ 3.050000000000e-06 0.000000
+ 3.059999000000e-06 0.000000
+ 3.060000000000e-06 3.300000
+ 3.069999000000e-06 3.300000
+ 3.070000000000e-06 0.000000
+ 3.079999000000e-06 0.000000
+ 3.080000000000e-06 3.300000
+ 3.089999000000e-06 3.300000
+ 3.090000000000e-06 0.000000
+ 3.099999000000e-06 0.000000
+ 3.100000000000e-06 3.300000
+ 3.109999000000e-06 3.300000
+ 3.110000000000e-06 0.000000
+ 3.119999000000e-06 0.000000
+ 3.120000000000e-06 3.300000
+ 3.129999000000e-06 3.300000
+ 3.130000000000e-06 0.000000
+ 3.139999000000e-06 0.000000
+ 3.140000000000e-06 3.300000
+ 3.149999000000e-06 3.300000
+ 3.150000000000e-06 0.000000
+ 3.159999000000e-06 0.000000
+ 3.160000000000e-06 3.300000
+ 3.169999000000e-06 3.300000
+ 3.170000000000e-06 0.000000
+ 3.179999000000e-06 0.000000
+ 3.180000000000e-06 3.300000
+ 3.189999000000e-06 3.300000
+ 3.190000000000e-06 0.000000
+ 3.199999000000e-06 0.000000
+ 3.200000000000e-06 3.300000
+ 3.209999000000e-06 3.300000
+ 3.210000000000e-06 0.000000
+ 3.219999000000e-06 0.000000
+ 3.220000000000e-06 3.300000
+ 3.229999000000e-06 3.300000
+ 3.230000000000e-06 0.000000
+ 3.239999000000e-06 0.000000
+ 3.240000000000e-06 3.300000
+ 3.249999000000e-06 3.300000
+ 3.250000000000e-06 0.000000
+ 3.259999000000e-06 0.000000
+ 3.260000000000e-06 3.300000
+ 3.269999000000e-06 3.300000
+ 3.270000000000e-06 0.000000
+ 3.279999000000e-06 0.000000
+ 3.280000000000e-06 3.300000
+ 3.289999000000e-06 3.300000
+ 3.290000000000e-06 0.000000
+ 3.299999000000e-06 0.000000
+ 3.300000000000e-06 3.300000
+ 3.309999000000e-06 3.300000
+ 3.310000000000e-06 0.000000
+ 3.319999000000e-06 0.000000
+ 3.320000000000e-06 3.300000
+ 3.329999000000e-06 3.300000
+ 3.330000000000e-06 0.000000
+ 3.339999000000e-06 0.000000
+ 3.340000000000e-06 3.300000
+ 3.349999000000e-06 3.300000
+ 3.350000000000e-06 0.000000
+ 3.359999000000e-06 0.000000
+ 3.360000000000e-06 3.300000
+ 3.369999000000e-06 3.300000
+ 3.370000000000e-06 0.000000
+ 3.379999000000e-06 0.000000
+ 3.380000000000e-06 3.300000
+ 3.389999000000e-06 3.300000
+ 3.390000000000e-06 0.000000
+ 3.399999000000e-06 0.000000
+ 3.400000000000e-06 3.300000
+ 3.409999000000e-06 3.300000
+ 3.410000000000e-06 0.000000
+ 3.419999000000e-06 0.000000
+ 3.420000000000e-06 3.300000
+ 3.429999000000e-06 3.300000
+ 3.430000000000e-06 0.000000
+ 3.439999000000e-06 0.000000
+ 3.440000000000e-06 3.300000
+ 3.449999000000e-06 3.300000
+ 3.450000000000e-06 0.000000
+ 3.459999000000e-06 0.000000
+ 3.460000000000e-06 3.300000
+ 3.469999000000e-06 3.300000
+ 3.470000000000e-06 0.000000
+ 3.479999000000e-06 0.000000
+ 3.480000000000e-06 3.300000
+ 3.489999000000e-06 3.300000
+ 3.490000000000e-06 0.000000
+ 3.499999000000e-06 0.000000
+ 3.500000000000e-06 3.300000
+ 3.509999000000e-06 3.300000
+ 3.510000000000e-06 0.000000
+ 3.519999000000e-06 0.000000
+ 3.520000000000e-06 3.300000
+ 3.529999000000e-06 3.300000
+ 3.530000000000e-06 0.000000
+ 3.539999000000e-06 0.000000
+ 3.540000000000e-06 3.300000
+ 3.549999000000e-06 3.300000
+ 3.550000000000e-06 0.000000
+ 3.559999000000e-06 0.000000
+ 3.560000000000e-06 3.300000
+ 3.569999000000e-06 3.300000
+ 3.570000000000e-06 0.000000
+ 3.579999000000e-06 0.000000
+ 3.580000000000e-06 3.300000
+ 3.589999000000e-06 3.300000
+ 3.590000000000e-06 0.000000
+ 3.599999000000e-06 0.000000
+ 3.600000000000e-06 3.300000
+ 3.609999000000e-06 3.300000
+ 3.610000000000e-06 0.000000
+ 3.619999000000e-06 0.000000
+ 3.620000000000e-06 3.300000
+ 3.629999000000e-06 3.300000
+ 3.630000000000e-06 0.000000
+ 3.639999000000e-06 0.000000
+ 3.640000000000e-06 3.300000
+ 3.649999000000e-06 3.300000
+ 3.650000000000e-06 0.000000
+ 3.659999000000e-06 0.000000
+ 3.660000000000e-06 3.300000
+ 3.669999000000e-06 3.300000
+ 3.670000000000e-06 0.000000
+ 3.679999000000e-06 0.000000
+ 3.680000000000e-06 3.300000
+ 3.689999000000e-06 3.300000
+ 3.690000000000e-06 0.000000
+ 3.699999000000e-06 0.000000
+ 3.700000000000e-06 3.300000
+ 3.709999000000e-06 3.300000
+ 3.710000000000e-06 0.000000
+ 3.719999000000e-06 0.000000
+ 3.720000000000e-06 3.300000
+ 3.729999000000e-06 3.300000
+ 3.730000000000e-06 0.000000
+ 3.739999000000e-06 0.000000
+ 3.740000000000e-06 3.300000
+ 3.749999000000e-06 3.300000
+ 3.750000000000e-06 0.000000
+ 3.759999000000e-06 0.000000
+ 3.760000000000e-06 3.300000
+ 3.769999000000e-06 3.300000
+ 3.770000000000e-06 0.000000
+ 3.779999000000e-06 0.000000
+ 3.780000000000e-06 3.300000
+ 3.789999000000e-06 3.300000
+ 3.790000000000e-06 0.000000
+ 3.799999000000e-06 0.000000
+ 3.800000000000e-06 3.300000
+ 3.809999000000e-06 3.300000
+ 3.810000000000e-06 0.000000
+ 3.819999000000e-06 0.000000
+ 3.820000000000e-06 3.300000
+ 3.829999000000e-06 3.300000
+ 3.830000000000e-06 0.000000
+ 3.839999000000e-06 0.000000
+ 3.840000000000e-06 3.300000
+ 3.849999000000e-06 3.300000
+ 3.850000000000e-06 0.000000
+ 3.859999000000e-06 0.000000
+ 3.860000000000e-06 3.300000
+ 3.869999000000e-06 3.300000
+ 3.870000000000e-06 0.000000
+ 3.879999000000e-06 0.000000
+ 3.880000000000e-06 3.300000
+ 3.889999000000e-06 3.300000
+ 3.890000000000e-06 0.000000
+ 3.899999000000e-06 0.000000
+ 3.900000000000e-06 3.300000
+ 3.909999000000e-06 3.300000
+ 3.910000000000e-06 0.000000
+ 3.919999000000e-06 0.000000
+ 3.920000000000e-06 3.300000
+ 3.929999000000e-06 3.300000
+ 3.930000000000e-06 0.000000
+ 3.939999000000e-06 0.000000
+ 3.940000000000e-06 3.300000
+ 3.949999000000e-06 3.300000
+ 3.950000000000e-06 0.000000
+ 3.959999000000e-06 0.000000
+ 3.960000000000e-06 3.300000
+ 3.969999000000e-06 3.300000
+ 3.970000000000e-06 0.000000
+ 3.979999000000e-06 0.000000
+ 3.980000000000e-06 3.300000
+ 3.989999000000e-06 3.300000
+ 3.990000000000e-06 0.000000
+ 3.999999000000e-06 0.000000
+ 4.000000000000e-06 3.300000
+ 4.009999000000e-06 3.300000
+ 4.010000000000e-06 0.000000
+ 4.019999000000e-06 0.000000
+ 4.020000000000e-06 3.300000
+ 4.029999000000e-06 3.300000
+ 4.030000000000e-06 0.000000
+ 4.039999000000e-06 0.000000
+ 4.040000000000e-06 3.300000
+ 4.049999000000e-06 3.300000
+ 4.050000000000e-06 0.000000
+ 4.059999000000e-06 0.000000
+ 4.060000000000e-06 3.300000
+ 4.069999000000e-06 3.300000
+ 4.070000000000e-06 0.000000
+ 4.079999000000e-06 0.000000
+ 4.080000000000e-06 3.300000
+ 4.089999000000e-06 3.300000
+ 4.090000000000e-06 0.000000
+ 4.099999000000e-06 0.000000
+ 4.100000000000e-06 3.300000
+ 4.109999000000e-06 3.300000
+ 4.110000000000e-06 0.000000
+ 4.119999000000e-06 0.000000
+ 4.120000000000e-06 3.300000
+ 4.129999000000e-06 3.300000
+ 4.130000000000e-06 0.000000
+ 4.139999000000e-06 0.000000
+ 4.140000000000e-06 3.300000
+ 4.149999000000e-06 3.300000
+ 4.150000000000e-06 0.000000
+ 4.159999000000e-06 0.000000
+ 4.160000000000e-06 3.300000
+ 4.169999000000e-06 3.300000
+ 4.170000000000e-06 0.000000
+ 4.179999000000e-06 0.000000
+ 4.180000000000e-06 3.300000
+ 4.189999000000e-06 3.300000
+ 4.190000000000e-06 0.000000
+ 4.199999000000e-06 0.000000
+ 4.200000000000e-06 3.300000
+ 4.209999000000e-06 3.300000
+ 4.210000000000e-06 0.000000
+ 4.219999000000e-06 0.000000
+ 4.220000000000e-06 3.300000
+ 4.229999000000e-06 3.300000
+ 4.230000000000e-06 0.000000
+ 4.239999000000e-06 0.000000
+ 4.240000000000e-06 3.300000
+ 4.249999000000e-06 3.300000
+ 4.250000000000e-06 0.000000
+ 4.259999000000e-06 0.000000
+ 4.260000000000e-06 3.300000
+ 4.269999000000e-06 3.300000
+ 4.270000000000e-06 0.000000
+ 4.279999000000e-06 0.000000
+ 4.280000000000e-06 3.300000
+ 4.289999000000e-06 3.300000
+ 4.290000000000e-06 0.000000
+ 4.299999000000e-06 0.000000
+ 4.300000000000e-06 3.300000
+ 4.309999000000e-06 3.300000
+ 4.310000000000e-06 0.000000
+ 4.319999000000e-06 0.000000
+ 4.320000000000e-06 3.300000
+ 4.329999000000e-06 3.300000
+ 4.330000000000e-06 0.000000
+ 4.339999000000e-06 0.000000
+ 4.340000000000e-06 3.300000
+ 4.349999000000e-06 3.300000
+ 4.350000000000e-06 0.000000
+ 4.359999000000e-06 0.000000
+ 4.360000000000e-06 3.300000
+ 4.369999000000e-06 3.300000
+ 4.370000000000e-06 0.000000
+ 4.379999000000e-06 0.000000
+ 4.380000000000e-06 3.300000
+ 4.389999000000e-06 3.300000
+ 4.390000000000e-06 0.000000
+ 4.399999000000e-06 0.000000
+ 4.400000000000e-06 3.300000
+ 4.409999000000e-06 3.300000
+ 4.410000000000e-06 0.000000
+ 4.419999000000e-06 0.000000
+ 4.420000000000e-06 3.300000
+ 4.429999000000e-06 3.300000
+ 4.430000000000e-06 0.000000
+ 4.439999000000e-06 0.000000
+ 4.440000000000e-06 3.300000
+ 4.449999000000e-06 3.300000
+ 4.450000000000e-06 0.000000
+ 4.459999000000e-06 0.000000
+ 4.460000000000e-06 3.300000
+ 4.469999000000e-06 3.300000
+ 4.470000000000e-06 0.000000
+ 4.479999000000e-06 0.000000
+ 4.480000000000e-06 3.300000
+ 4.489999000000e-06 3.300000
+ 4.490000000000e-06 0.000000
+ 4.499999000000e-06 0.000000
+ 4.500000000000e-06 3.300000
+ 4.509999000000e-06 3.300000
+ 4.510000000000e-06 0.000000
+ 4.519999000000e-06 0.000000
+ 4.520000000000e-06 3.300000
+ 4.529999000000e-06 3.300000
+ 4.530000000000e-06 0.000000
+ 4.539999000000e-06 0.000000
+ 4.540000000000e-06 3.300000
+ 4.549999000000e-06 3.300000
+ 4.550000000000e-06 0.000000
+ 4.559999000000e-06 0.000000
+ 4.560000000000e-06 3.300000
+ 4.569999000000e-06 3.300000
+ 4.570000000000e-06 0.000000
+ 4.579999000000e-06 0.000000
+ 4.580000000000e-06 3.300000
+ 4.589999000000e-06 3.300000
+ 4.590000000000e-06 0.000000
+ 4.599999000000e-06 0.000000
+ 4.600000000000e-06 3.300000
+ 4.609999000000e-06 3.300000
+ 4.610000000000e-06 0.000000
+ 4.619999000000e-06 0.000000
+ 4.620000000000e-06 3.300000
+ 4.629999000000e-06 3.300000
+ 4.630000000000e-06 0.000000
+ 4.639999000000e-06 0.000000
+ 4.640000000000e-06 3.300000
+ 4.649999000000e-06 3.300000
+ 4.650000000000e-06 0.000000
+ 4.659999000000e-06 0.000000
+ 4.660000000000e-06 3.300000
+ 4.669999000000e-06 3.300000
+ 4.670000000000e-06 0.000000
+ 4.679999000000e-06 0.000000
+ 4.680000000000e-06 3.300000
+ 4.689999000000e-06 3.300000
+ 4.690000000000e-06 0.000000
+ 4.699999000000e-06 0.000000
+ 4.700000000000e-06 3.300000
+ 4.709999000000e-06 3.300000
+ 4.710000000000e-06 0.000000
+ 4.719999000000e-06 0.000000
+ 4.720000000000e-06 3.300000
+ 4.729999000000e-06 3.300000
+ 4.730000000000e-06 0.000000
+ 4.739999000000e-06 0.000000
+ 4.740000000000e-06 3.300000
+ 4.749999000000e-06 3.300000
+ 4.750000000000e-06 0.000000
+ 4.759999000000e-06 0.000000
+ 4.760000000000e-06 3.300000
+ 4.769999000000e-06 3.300000
+ 4.770000000000e-06 0.000000
+ 4.779999000000e-06 0.000000
+ 4.780000000000e-06 3.300000
+ 4.789999000000e-06 3.300000
+ 4.790000000000e-06 0.000000
+ 4.799999000000e-06 0.000000
+ 4.800000000000e-06 3.300000
+ 4.809999000000e-06 3.300000
+ 4.810000000000e-06 0.000000
+ 4.819999000000e-06 0.000000
+ 4.820000000000e-06 3.300000
+ 4.829999000000e-06 3.300000
+ 4.830000000000e-06 0.000000
+ 4.839999000000e-06 0.000000
+ 4.840000000000e-06 3.300000
+ 4.849999000000e-06 3.300000
+ 4.850000000000e-06 0.000000
+ 4.859999000000e-06 0.000000
+ 4.860000000000e-06 3.300000
+ 4.869999000000e-06 3.300000
+ 4.870000000000e-06 0.000000
+ 4.879999000000e-06 0.000000
+ 4.880000000000e-06 3.300000
+ 4.889999000000e-06 3.300000
+ 4.890000000000e-06 0.000000
+ 4.899999000000e-06 0.000000
+ 4.900000000000e-06 3.300000
+ 4.909999000000e-06 3.300000
+ 4.910000000000e-06 0.000000
+ 4.919999000000e-06 0.000000
+ 4.920000000000e-06 3.300000
+ 4.929999000000e-06 3.300000
+ 4.930000000000e-06 0.000000
+ 4.939999000000e-06 0.000000
+ 4.940000000000e-06 3.300000
+ 4.949999000000e-06 3.300000
+ 4.950000000000e-06 0.000000
+ 4.959999000000e-06 0.000000
+ 4.960000000000e-06 3.300000
+ 4.969999000000e-06 3.300000
+ 4.970000000000e-06 0.000000
+ 4.979999000000e-06 0.000000
+ 4.980000000000e-06 3.300000
+ 4.989999000000e-06 3.300000
+ 4.990000000000e-06 0.000000
+ 4.999999000000e-06 0.000000
+ 5.000000000000e-06 3.300000
+ 5.009999000000e-06 3.300000
+ 5.010000000000e-06 0.000000
+ 5.019999000000e-06 0.000000
+ 5.020000000000e-06 3.300000
+ 5.029999000000e-06 3.300000
+ 5.030000000000e-06 0.000000
+ 5.039999000000e-06 0.000000
+ 5.040000000000e-06 3.300000
+ 5.049999000000e-06 3.300000
+ 5.050000000000e-06 0.000000
+ 5.059999000000e-06 0.000000
+ 5.060000000000e-06 3.300000
+ 5.069999000000e-06 3.300000
+ 5.070000000000e-06 0.000000
+ 5.079999000000e-06 0.000000
+ 5.080000000000e-06 3.300000
+ 5.089999000000e-06 3.300000
+ 5.090000000000e-06 0.000000
+ 5.099999000000e-06 0.000000
+ 5.100000000000e-06 3.300000
+ 5.109999000000e-06 3.300000
+ 5.110000000000e-06 0.000000
+ 5.119999000000e-06 0.000000
+ 5.120000000000e-06 3.300000
+ 5.129999000000e-06 3.300000
+ 5.130000000000e-06 0.000000
+ 5.139999000000e-06 0.000000
+ 5.140000000000e-06 3.300000
+ 5.149999000000e-06 3.300000
+ 5.150000000000e-06 0.000000
+ 5.159999000000e-06 0.000000
+ 5.160000000000e-06 3.300000
+ 5.169999000000e-06 3.300000
+ 5.170000000000e-06 0.000000
+ 5.179999000000e-06 0.000000
+ 5.180000000000e-06 3.300000
+ 5.189999000000e-06 3.300000
+ 5.190000000000e-06 0.000000
+ 5.199999000000e-06 0.000000
+ 5.200000000000e-06 3.300000
+ 5.209999000000e-06 3.300000
+ 5.210000000000e-06 0.000000
+ 5.219999000000e-06 0.000000
+ 5.220000000000e-06 3.300000
+ 5.229999000000e-06 3.300000
+ 5.230000000000e-06 0.000000
+ 5.239999000000e-06 0.000000
+ 5.240000000000e-06 3.300000
+ 5.249999000000e-06 3.300000
+ 5.250000000000e-06 0.000000
+ 5.259999000000e-06 0.000000
+ 5.260000000000e-06 3.300000
+ 5.269999000000e-06 3.300000
+ 5.270000000000e-06 0.000000
+ 5.279999000000e-06 0.000000
+ 5.280000000000e-06 3.300000
+ 5.289999000000e-06 3.300000
+ 5.290000000000e-06 0.000000
+ 5.299999000000e-06 0.000000
+ 5.300000000000e-06 3.300000
+ 5.309999000000e-06 3.300000
+ 5.310000000000e-06 0.000000
+ 5.319999000000e-06 0.000000
+ 5.320000000000e-06 3.300000
+ 5.329999000000e-06 3.300000
+ 5.330000000000e-06 0.000000
+ 5.339999000000e-06 0.000000
+ 5.340000000000e-06 3.300000
+ 5.349999000000e-06 3.300000
+ 5.350000000000e-06 0.000000
+ 5.359999000000e-06 0.000000
+ 5.360000000000e-06 3.300000
+ 5.369999000000e-06 3.300000
+ 5.370000000000e-06 0.000000
+ 5.379999000000e-06 0.000000
+ 5.380000000000e-06 3.300000
+ 5.389999000000e-06 3.300000
+ 5.390000000000e-06 0.000000
+ 5.399999000000e-06 0.000000
+ 5.400000000000e-06 3.300000
+ 5.409999000000e-06 3.300000
+ 5.410000000000e-06 0.000000
+ 5.419999000000e-06 0.000000
+ 5.420000000000e-06 3.300000
+ 5.429999000000e-06 3.300000
+ 5.430000000000e-06 0.000000
+ 5.439999000000e-06 0.000000
+ 5.440000000000e-06 3.300000
+ 5.449999000000e-06 3.300000
+ 5.450000000000e-06 0.000000
+ 5.459999000000e-06 0.000000
+ 5.460000000000e-06 3.300000
+ 5.469999000000e-06 3.300000
+ 5.470000000000e-06 0.000000
+ 5.479999000000e-06 0.000000
+ 5.480000000000e-06 3.300000
+ 5.489999000000e-06 3.300000
+ 5.490000000000e-06 0.000000
+ 5.499999000000e-06 0.000000
+ 5.500000000000e-06 3.300000
+ 5.509999000000e-06 3.300000
+ 5.510000000000e-06 0.000000
+ 5.519999000000e-06 0.000000
+ 5.520000000000e-06 3.300000
+ 5.529999000000e-06 3.300000
+ 5.530000000000e-06 0.000000
+ 5.539999000000e-06 0.000000
+ 5.540000000000e-06 3.300000
+ 5.549999000000e-06 3.300000
+ 5.550000000000e-06 0.000000
+ 5.559999000000e-06 0.000000
+ 5.560000000000e-06 3.300000
+ 5.569999000000e-06 3.300000
+ 5.570000000000e-06 0.000000
+ 5.579999000000e-06 0.000000
+ 5.580000000000e-06 3.300000
+ 5.589999000000e-06 3.300000
+ 5.590000000000e-06 0.000000
+ 5.599999000000e-06 0.000000
+ 5.600000000000e-06 3.300000
+ 5.609999000000e-06 3.300000
+ 5.610000000000e-06 0.000000
+ 5.619999000000e-06 0.000000
+ 5.620000000000e-06 3.300000
+ 5.629999000000e-06 3.300000
+ 5.630000000000e-06 0.000000
+ 5.639999000000e-06 0.000000
+ 5.640000000000e-06 3.300000
+ 5.649999000000e-06 3.300000
+ 5.650000000000e-06 0.000000
+ 5.659999000000e-06 0.000000
+ 5.660000000000e-06 3.300000
+ 5.669999000000e-06 3.300000
+ 5.670000000000e-06 0.000000
+ 5.679999000000e-06 0.000000
+ 5.680000000000e-06 3.300000
+ 5.689999000000e-06 3.300000
+ 5.690000000000e-06 0.000000
+ 5.699999000000e-06 0.000000
+ 5.700000000000e-06 3.300000
+ 5.709999000000e-06 3.300000
+ 5.710000000000e-06 0.000000
+ 5.719999000000e-06 0.000000
+ 5.720000000000e-06 3.300000
+ 5.729999000000e-06 3.300000
+ 5.730000000000e-06 0.000000
+ 5.739999000000e-06 0.000000
+ 5.740000000000e-06 3.300000
+ 5.749999000000e-06 3.300000
+ 5.750000000000e-06 0.000000
+ 5.759999000000e-06 0.000000
+ 5.760000000000e-06 3.300000
+ 5.769999000000e-06 3.300000
+ 5.770000000000e-06 0.000000
+ 5.779999000000e-06 0.000000
+ 5.780000000000e-06 3.300000
+ 5.789999000000e-06 3.300000
+ 5.790000000000e-06 0.000000
+ 5.799999000000e-06 0.000000
+ 5.800000000000e-06 3.300000
+ 5.809999000000e-06 3.300000
+ 5.810000000000e-06 0.000000
+ 5.819999000000e-06 0.000000
+ 5.820000000000e-06 3.300000
+ 5.829999000000e-06 3.300000
+ 5.830000000000e-06 0.000000
+ 5.839999000000e-06 0.000000
+ 5.840000000000e-06 3.300000
+ 5.849999000000e-06 3.300000
+ 5.850000000000e-06 0.000000
+ 5.859999000000e-06 0.000000
+ 5.860000000000e-06 3.300000
+ 5.869999000000e-06 3.300000
+ 5.870000000000e-06 0.000000
+ 5.879999000000e-06 0.000000
+ 5.880000000000e-06 3.300000
+ 5.889999000000e-06 3.300000
+ 5.890000000000e-06 0.000000
+ 5.899999000000e-06 0.000000
+ 5.900000000000e-06 3.300000
+ 5.909999000000e-06 3.300000
+ 5.910000000000e-06 0.000000
+ 5.919999000000e-06 0.000000
+ 5.920000000000e-06 3.300000
+ 5.929999000000e-06 3.300000
+ 5.930000000000e-06 0.000000
+ 5.939999000000e-06 0.000000
+ 5.940000000000e-06 3.300000
+ 5.949999000000e-06 3.300000
+ 5.950000000000e-06 0.000000
+ 5.959999000000e-06 0.000000
+ 5.960000000000e-06 3.300000
+ 5.969999000000e-06 3.300000
+ 5.970000000000e-06 0.000000
+ 5.979999000000e-06 0.000000
+ 5.980000000000e-06 3.300000
+ 5.989999000000e-06 3.300000
+ 5.990000000000e-06 0.000000
+ 5.999999000000e-06 0.000000
+ 6.000000000000e-06 3.300000
+ 6.009999000000e-06 3.300000
+ 6.010000000000e-06 0.000000
+ 6.019999000000e-06 0.000000
+ 6.020000000000e-06 3.300000
+ 6.029999000000e-06 3.300000
+ 6.030000000000e-06 0.000000
+ 6.039999000000e-06 0.000000
+ 6.040000000000e-06 3.300000
+ 6.049999000000e-06 3.300000
+ 6.050000000000e-06 0.000000
+ 6.059999000000e-06 0.000000
+ 6.060000000000e-06 3.300000
+ 6.069999000000e-06 3.300000
+ 6.070000000000e-06 0.000000
+ 6.079999000000e-06 0.000000
+ 6.080000000000e-06 3.300000
+ 6.089999000000e-06 3.300000
+ 6.090000000000e-06 0.000000
+ 6.099999000000e-06 0.000000
+ 6.100000000000e-06 3.300000
+ 6.109999000000e-06 3.300000
+ 6.110000000000e-06 0.000000
+ 6.119999000000e-06 0.000000
+ 6.120000000000e-06 3.300000
+ 6.129999000000e-06 3.300000
+ 6.130000000000e-06 0.000000
+ 6.139999000000e-06 0.000000
+ 6.140000000000e-06 3.300000
+ 6.149999000000e-06 3.300000
+ 6.150000000000e-06 0.000000
+ 6.159999000000e-06 0.000000
+ 6.160000000000e-06 3.300000
+ 6.169999000000e-06 3.300000
+ 6.170000000000e-06 0.000000
+ 6.179999000000e-06 0.000000
+ 6.180000000000e-06 3.300000
+ 6.189999000000e-06 3.300000
+ 6.190000000000e-06 0.000000
+ 6.199999000000e-06 0.000000
+ 6.200000000000e-06 3.300000
+ 6.209999000000e-06 3.300000
+ 6.210000000000e-06 0.000000
+ 6.219999000000e-06 0.000000
+ 6.220000000000e-06 3.300000
+ 6.229999000000e-06 3.300000
+ 6.230000000000e-06 0.000000
+ 6.239999000000e-06 0.000000
+ 6.240000000000e-06 3.300000
+ 6.249999000000e-06 3.300000
+ 6.250000000000e-06 0.000000
+ 6.259999000000e-06 0.000000
+ 6.260000000000e-06 3.300000
+ 6.269999000000e-06 3.300000
+ 6.270000000000e-06 0.000000
+ 6.279999000000e-06 0.000000
+ 6.280000000000e-06 3.300000
+ 6.289999000000e-06 3.300000
+ 6.290000000000e-06 0.000000
+ 6.299999000000e-06 0.000000
+ 6.300000000000e-06 3.300000
+ 6.309999000000e-06 3.300000
+ 6.310000000000e-06 0.000000
+ 6.319999000000e-06 0.000000
+ 6.320000000000e-06 3.300000
+ 6.329999000000e-06 3.300000
+ 6.330000000000e-06 0.000000
+ 6.339999000000e-06 0.000000
+ 6.340000000000e-06 3.300000
+ 6.349999000000e-06 3.300000
+ 6.350000000000e-06 0.000000
+ 6.359999000000e-06 0.000000
+ 6.360000000000e-06 3.300000
+ 6.369999000000e-06 3.300000
+ 6.370000000000e-06 0.000000
+ 6.379999000000e-06 0.000000
+ 6.380000000000e-06 3.300000
+ 6.389999000000e-06 3.300000
+ 6.390000000000e-06 0.000000
+ 6.399999000000e-06 0.000000
+ 6.400000000000e-06 3.300000
+ 6.409999000000e-06 3.300000
+ 6.410000000000e-06 0.000000
+ 6.419999000000e-06 0.000000
+ 6.420000000000e-06 3.300000
+ 6.429999000000e-06 3.300000
+ 6.430000000000e-06 0.000000
+ 6.439999000000e-06 0.000000
+ 6.440000000000e-06 3.300000
+ 6.449999000000e-06 3.300000
+ 6.450000000000e-06 0.000000
+ 6.459999000000e-06 0.000000
+ 6.460000000000e-06 3.300000
+ 6.469999000000e-06 3.300000
+ 6.470000000000e-06 0.000000
+ 6.479999000000e-06 0.000000
+ 6.480000000000e-06 3.300000
+ 6.489999000000e-06 3.300000
+ 6.490000000000e-06 0.000000
+ 6.499999000000e-06 0.000000
+ 6.500000000000e-06 3.300000
+ 6.509999000000e-06 3.300000
+ 6.510000000000e-06 0.000000
+ 6.519999000000e-06 0.000000
+ 6.520000000000e-06 3.300000
+ 6.529999000000e-06 3.300000
+ 6.530000000000e-06 0.000000
+ 6.539999000000e-06 0.000000
+ 6.540000000000e-06 3.300000
+ 6.549999000000e-06 3.300000
+ 6.550000000000e-06 0.000000
+ 6.559999000000e-06 0.000000
+ 6.560000000000e-06 3.300000
+ 6.569999000000e-06 3.300000
+ 6.570000000000e-06 0.000000
+ 6.579999000000e-06 0.000000
+ 6.580000000000e-06 3.300000
+ 6.589999000000e-06 3.300000
+ 6.590000000000e-06 0.000000
+ 6.599999000000e-06 0.000000
+ 6.600000000000e-06 3.300000
+ 6.609999000000e-06 3.300000
+ 6.610000000000e-06 0.000000
+ 6.619999000000e-06 0.000000
+ 6.620000000000e-06 3.300000
+ 6.629999000000e-06 3.300000
+ 6.630000000000e-06 0.000000
+ 6.639999000000e-06 0.000000
+ 6.640000000000e-06 3.300000
+ 6.649999000000e-06 3.300000
+ 6.650000000000e-06 0.000000
+ 6.659999000000e-06 0.000000
+ 6.660000000000e-06 3.300000
+ 6.669999000000e-06 3.300000
+ 6.670000000000e-06 0.000000
+ 6.679999000000e-06 0.000000
+ 6.680000000000e-06 3.300000
+ 6.689999000000e-06 3.300000
+ 6.690000000000e-06 0.000000
+ 6.699999000000e-06 0.000000
+ 6.700000000000e-06 3.300000
+ 6.709999000000e-06 3.300000
+ 6.710000000000e-06 0.000000
+ 6.719999000000e-06 0.000000
+ 6.720000000000e-06 3.300000
+ 6.729999000000e-06 3.300000
+ 6.730000000000e-06 0.000000
+ 6.739999000000e-06 0.000000
+ 6.740000000000e-06 3.300000
+ 6.749999000000e-06 3.300000
+ 6.750000000000e-06 0.000000
+ 6.759999000000e-06 0.000000
+ 6.760000000000e-06 3.300000
+ 6.769999000000e-06 3.300000
+ 6.770000000000e-06 0.000000
+ 6.779999000000e-06 0.000000
+ 6.780000000000e-06 3.300000
+ 6.789999000000e-06 3.300000
+ 6.790000000000e-06 0.000000
+ 6.799999000000e-06 0.000000
+ 6.800000000000e-06 3.300000
+ 6.809999000000e-06 3.300000
+ 6.810000000000e-06 0.000000
+ 6.819999000000e-06 0.000000
+ 6.820000000000e-06 3.300000
+ 6.829999000000e-06 3.300000
+ 6.830000000000e-06 0.000000
+ 6.839999000000e-06 0.000000
+ 6.840000000000e-06 3.300000
+ 6.849999000000e-06 3.300000
+ 6.850000000000e-06 0.000000
+ 6.859999000000e-06 0.000000
+ 6.860000000000e-06 3.300000
+ 6.869999000000e-06 3.300000
+ 6.870000000000e-06 0.000000
+ 6.879999000000e-06 0.000000
+ 6.880000000000e-06 3.300000
+ 6.889999000000e-06 3.300000
+ 6.890000000000e-06 0.000000
+ 6.899999000000e-06 0.000000
+ 6.900000000000e-06 3.300000
+ 6.909999000000e-06 3.300000
+ 6.910000000000e-06 0.000000
+ 6.919999000000e-06 0.000000
+ 6.920000000000e-06 3.300000
+ 6.929999000000e-06 3.300000
+ 6.930000000000e-06 0.000000
+ 6.939999000000e-06 0.000000
+ 6.940000000000e-06 3.300000
+ 6.949999000000e-06 3.300000
+ 6.950000000000e-06 0.000000
+ 6.959999000000e-06 0.000000
+ 6.960000000000e-06 3.300000
+ 6.969999000000e-06 3.300000
+ 6.970000000000e-06 0.000000
+ 6.979999000000e-06 0.000000
+ 6.980000000000e-06 3.300000
+ 6.989999000000e-06 3.300000
+ 6.990000000000e-06 0.000000
+ 6.999999000000e-06 0.000000
+ 7.000000000000e-06 3.300000
+ 7.009999000000e-06 3.300000
+ 7.010000000000e-06 0.000000
+ 7.019999000000e-06 0.000000
+ 7.020000000000e-06 3.300000
+ 7.029999000000e-06 3.300000
+ 7.030000000000e-06 0.000000
+ 7.039999000000e-06 0.000000
+ 7.040000000000e-06 3.300000
+ 7.049999000000e-06 3.300000
+ 7.050000000000e-06 0.000000
+ 7.059999000000e-06 0.000000
+ 7.060000000000e-06 3.300000
+ 7.069999000000e-06 3.300000
+ 7.070000000000e-06 0.000000
+ 7.079999000000e-06 0.000000
+ 7.080000000000e-06 3.300000
+ 7.089999000000e-06 3.300000
+ 7.090000000000e-06 0.000000
+ 7.099999000000e-06 0.000000
+ 7.100000000000e-06 3.300000
+ 7.109999000000e-06 3.300000
+ 7.110000000000e-06 0.000000
+ 7.119999000000e-06 0.000000
+ 7.120000000000e-06 3.300000
+ 7.129999000000e-06 3.300000
+ 7.130000000000e-06 0.000000
+ 7.139999000000e-06 0.000000
+ 7.140000000000e-06 3.300000
+ 7.149999000000e-06 3.300000
+ 7.150000000000e-06 0.000000
+ 7.159999000000e-06 0.000000
+ 7.160000000000e-06 3.300000
+ 7.169999000000e-06 3.300000
+ 7.170000000000e-06 0.000000
+ 7.179999000000e-06 0.000000
+ 7.180000000000e-06 3.300000
+ 7.189999000000e-06 3.300000
+ 7.190000000000e-06 0.000000
+ 7.199999000000e-06 0.000000
+ 7.200000000000e-06 3.300000
+ 7.209999000000e-06 3.300000
+ 7.210000000000e-06 0.000000
+ 7.219999000000e-06 0.000000
+ 7.220000000000e-06 3.300000
+ 7.229999000000e-06 3.300000
+ 7.230000000000e-06 0.000000
+ 7.239999000000e-06 0.000000
+ 7.240000000000e-06 3.300000
+ 7.249999000000e-06 3.300000
+ 7.250000000000e-06 0.000000
+ 7.259999000000e-06 0.000000
+ 7.260000000000e-06 3.300000
+ 7.269999000000e-06 3.300000
+ 7.270000000000e-06 0.000000
+ 7.279999000000e-06 0.000000
+ 7.280000000000e-06 3.300000
+ 7.289999000000e-06 3.300000
+ 7.290000000000e-06 0.000000
+ 7.299999000000e-06 0.000000
+ 7.300000000000e-06 3.300000
+ 7.309999000000e-06 3.300000
+ 7.310000000000e-06 0.000000
+ 7.319999000000e-06 0.000000
+ 7.320000000000e-06 3.300000
+ 7.329999000000e-06 3.300000
+ 7.330000000000e-06 0.000000
+ 7.339999000000e-06 0.000000
+ 7.340000000000e-06 3.300000
+ 7.349999000000e-06 3.300000
+ 7.350000000000e-06 0.000000
+ 7.359999000000e-06 0.000000
+ 7.360000000000e-06 3.300000
+ 7.369999000000e-06 3.300000
+ 7.370000000000e-06 0.000000
+ 7.379999000000e-06 0.000000
+ 7.380000000000e-06 3.300000
+ 7.389999000000e-06 3.300000
+ 7.390000000000e-06 0.000000
+ 7.399999000000e-06 0.000000
+ 7.400000000000e-06 3.300000
+ 7.409999000000e-06 3.300000
+ 7.410000000000e-06 0.000000
+ 7.419999000000e-06 0.000000
+ 7.420000000000e-06 3.300000
+ 7.429999000000e-06 3.300000
+ 7.430000000000e-06 0.000000
+ 7.439999000000e-06 0.000000
+ 7.440000000000e-06 3.300000
+ 7.449999000000e-06 3.300000
+ 7.450000000000e-06 0.000000
+ 7.459999000000e-06 0.000000
+ 7.460000000000e-06 3.300000
+ 7.469999000000e-06 3.300000
+ 7.470000000000e-06 0.000000
+ 7.479999000000e-06 0.000000
+ 7.480000000000e-06 3.300000
+ 7.489999000000e-06 3.300000
+ 7.490000000000e-06 0.000000
+ 7.499999000000e-06 0.000000
+ 7.500000000000e-06 3.300000
+ 7.509999000000e-06 3.300000
+ 7.510000000000e-06 0.000000
+ 7.519999000000e-06 0.000000
+ 7.520000000000e-06 3.300000
+ 7.529999000000e-06 3.300000
+ 7.530000000000e-06 0.000000
+ 7.539999000000e-06 0.000000
+ 7.540000000000e-06 3.300000
+ 7.549999000000e-06 3.300000
+ 7.550000000000e-06 0.000000
+ 7.559999000000e-06 0.000000
+ 7.560000000000e-06 3.300000
+ 7.569999000000e-06 3.300000
+ 7.570000000000e-06 0.000000
+ 7.579999000000e-06 0.000000
+ 7.580000000000e-06 3.300000
+ 7.589999000000e-06 3.300000
+ 7.590000000000e-06 0.000000
+ 7.599999000000e-06 0.000000
+ 7.600000000000e-06 3.300000
+ 7.609999000000e-06 3.300000
+ 7.610000000000e-06 0.000000
+ 7.619999000000e-06 0.000000
+ 7.620000000000e-06 3.300000
+ 7.629999000000e-06 3.300000
+ 7.630000000000e-06 0.000000
+ 7.639999000000e-06 0.000000
+ 7.640000000000e-06 3.300000
+ 7.649999000000e-06 3.300000
+ 7.650000000000e-06 0.000000
+ 7.659999000000e-06 0.000000
+ 7.660000000000e-06 3.300000
+ 7.669999000000e-06 3.300000
+ 7.670000000000e-06 0.000000
+ 7.679999000000e-06 0.000000
+ 7.680000000000e-06 3.300000
+ 7.689999000000e-06 3.300000
+ 7.690000000000e-06 0.000000
+ 7.699999000000e-06 0.000000
+ 7.700000000000e-06 3.300000
+ 7.709999000000e-06 3.300000
+ 7.710000000000e-06 0.000000
+ 7.719999000000e-06 0.000000
+ 7.720000000000e-06 3.300000
+ 7.729999000000e-06 3.300000
+ 7.730000000000e-06 0.000000
+ 7.739999000000e-06 0.000000
+ 7.740000000000e-06 3.300000
+ 7.749999000000e-06 3.300000
+ 7.750000000000e-06 0.000000
+ 7.759999000000e-06 0.000000
+ 7.760000000000e-06 3.300000
+ 7.769999000000e-06 3.300000
+ 7.770000000000e-06 0.000000
+ 7.779999000000e-06 0.000000
+ 7.780000000000e-06 3.300000
+ 7.789999000000e-06 3.300000
+ 7.790000000000e-06 0.000000
+ 7.799999000000e-06 0.000000
+ 7.800000000000e-06 3.300000
+ 7.809999000000e-06 3.300000
+ 7.810000000000e-06 0.000000
+ 7.819999000000e-06 0.000000
+ 7.820000000000e-06 3.300000
+ 7.829999000000e-06 3.300000
+ 7.830000000000e-06 0.000000
+ 7.839999000000e-06 0.000000
+ 7.840000000000e-06 3.300000
+ 7.849999000000e-06 3.300000
+ 7.850000000000e-06 0.000000
+ 7.859999000000e-06 0.000000
+ 7.860000000000e-06 3.300000
+ 7.869999000000e-06 3.300000
+ 7.870000000000e-06 0.000000
+ 7.879999000000e-06 0.000000
+ 7.880000000000e-06 3.300000
+ 7.889999000000e-06 3.300000
+ 7.890000000000e-06 0.000000
+ 7.899999000000e-06 0.000000
+ 7.900000000000e-06 3.300000
+ 7.909999000000e-06 3.300000
+ 7.910000000000e-06 0.000000
+ 7.919999000000e-06 0.000000
+ 7.920000000000e-06 3.300000
+ 7.929999000000e-06 3.300000
+ 7.930000000000e-06 0.000000
+ 7.939999000000e-06 0.000000
+ 7.940000000000e-06 3.300000
+ 7.949999000000e-06 3.300000
+ 7.950000000000e-06 0.000000
+ 7.959999000000e-06 0.000000
+ 7.960000000000e-06 3.300000
+ 7.969999000000e-06 3.300000
+ 7.970000000000e-06 0.000000
+ 7.979999000000e-06 0.000000
+ 7.980000000000e-06 3.300000
+ 7.989999000000e-06 3.300000
+ 7.990000000000e-06 0.000000
+ 7.999999000000e-06 0.000000
+ 8.000000000000e-06 3.300000
+ 8.009999000000e-06 3.300000
+ 8.010000000000e-06 0.000000
+ 8.019999000000e-06 0.000000
+ 8.020000000000e-06 3.300000
+ 8.029999000000e-06 3.300000
+ 8.030000000000e-06 0.000000
+ 8.039999000000e-06 0.000000
+ 8.040000000000e-06 3.300000
+ 8.049999000000e-06 3.300000
+ 8.050000000000e-06 0.000000
+ 8.059999000000e-06 0.000000
+ 8.060000000000e-06 3.300000
+ 8.069999000000e-06 3.300000
+ 8.070000000000e-06 0.000000
+ 8.079999000000e-06 0.000000
+ 8.080000000000e-06 3.300000
+ 8.089999000000e-06 3.300000
+ 8.090000000000e-06 0.000000
+ 8.099999000000e-06 0.000000
+ 8.100000000000e-06 3.300000
+ 8.109999000000e-06 3.300000
+ 8.110000000000e-06 0.000000
+ 8.119999000000e-06 0.000000
+ 8.120000000000e-06 3.300000
+ 8.129999000000e-06 3.300000
+ 8.130000000000e-06 0.000000
+ 8.139999000000e-06 0.000000
+ 8.140000000000e-06 3.300000
+ 8.149999000000e-06 3.300000
+ 8.150000000000e-06 0.000000
+ 8.159999000000e-06 0.000000
+ 8.160000000000e-06 3.300000
+ 8.169999000000e-06 3.300000
+ 8.170000000000e-06 0.000000
+ 8.179999000000e-06 0.000000
+ 8.180000000000e-06 3.300000
+ 8.189999000000e-06 3.300000
+ 8.190000000000e-06 0.000000
+ 8.199999000000e-06 0.000000
+ 8.200000000000e-06 3.300000
+ 8.209999000000e-06 3.300000
+ 8.210000000000e-06 0.000000
+ 8.219999000000e-06 0.000000
+ 8.220000000000e-06 3.300000
+ 8.229999000000e-06 3.300000
+ 8.230000000000e-06 0.000000
+ 8.239999000000e-06 0.000000
+ 8.240000000000e-06 3.300000
+ 8.249999000000e-06 3.300000
+ 8.250000000000e-06 0.000000
+ 8.259999000000e-06 0.000000
+ 8.260000000000e-06 3.300000
+ 8.269999000000e-06 3.300000
+ 8.270000000000e-06 0.000000
+ 8.279999000000e-06 0.000000
+ 8.280000000000e-06 3.300000
+ 8.289999000000e-06 3.300000
+ 8.290000000000e-06 0.000000
+ 8.299999000000e-06 0.000000
+ 8.300000000000e-06 3.300000
+ 8.309999000000e-06 3.300000
+ 8.310000000000e-06 0.000000
+ 8.319999000000e-06 0.000000
+ 8.320000000000e-06 3.300000
+ 8.329999000000e-06 3.300000
+ 8.330000000000e-06 0.000000
+ 8.339999000000e-06 0.000000
+ 8.340000000000e-06 3.300000
+ 8.349999000000e-06 3.300000
+ 8.350000000000e-06 0.000000
+ 8.359999000000e-06 0.000000
+ 8.360000000000e-06 3.300000
+ 8.369999000000e-06 3.300000
+ 8.370000000000e-06 0.000000
+ 8.379999000000e-06 0.000000
+ 8.380000000000e-06 3.300000
+ 8.389999000000e-06 3.300000
+ 8.390000000000e-06 0.000000
+ 8.399999000000e-06 0.000000
+ 8.400000000000e-06 3.300000
+ 8.409999000000e-06 3.300000
+ 8.410000000000e-06 0.000000
+ 8.419999000000e-06 0.000000
+ 8.420000000000e-06 3.300000
+ 8.429999000000e-06 3.300000
+ 8.430000000000e-06 0.000000
+ 8.439999000000e-06 0.000000
+ 8.440000000000e-06 3.300000
+ 8.449999000000e-06 3.300000
+ 8.450000000000e-06 0.000000
+ 8.459999000000e-06 0.000000
+ 8.460000000000e-06 3.300000
+ 8.469999000000e-06 3.300000
+ 8.470000000000e-06 0.000000
+ 8.479999000000e-06 0.000000
+ 8.480000000000e-06 3.300000
+ 8.489999000000e-06 3.300000
+ 8.490000000000e-06 0.000000
+ 8.499999000000e-06 0.000000
+ 8.500000000000e-06 3.300000
+ 8.509999000000e-06 3.300000
+ 8.510000000000e-06 0.000000
+ 8.519999000000e-06 0.000000
+ 8.520000000000e-06 3.300000
+ 8.529999000000e-06 3.300000
+ 8.530000000000e-06 0.000000
+ 8.539999000000e-06 0.000000
+ 8.540000000000e-06 3.300000
+ 8.549999000000e-06 3.300000
+ 8.550000000000e-06 0.000000
+ 8.559999000000e-06 0.000000
+ 8.560000000000e-06 3.300000
+ 8.569999000000e-06 3.300000
+ 8.570000000000e-06 0.000000
+ 8.579999000000e-06 0.000000
+ 8.580000000000e-06 3.300000
+ 8.589999000000e-06 3.300000
+ 8.590000000000e-06 0.000000
+ 8.599999000000e-06 0.000000
+ 8.600000000000e-06 3.300000
+ 8.609999000000e-06 3.300000
+ 8.610000000000e-06 0.000000
+ 8.619999000000e-06 0.000000
+ 8.620000000000e-06 3.300000
+ 8.629999000000e-06 3.300000
+ 8.630000000000e-06 0.000000
+ 8.639999000000e-06 0.000000
+ 8.640000000000e-06 3.300000
+ 8.649999000000e-06 3.300000
+ 8.650000000000e-06 0.000000
+ 8.659999000000e-06 0.000000
+ 8.660000000000e-06 3.300000
+ 8.669999000000e-06 3.300000
+ 8.670000000000e-06 0.000000
+ 8.679999000000e-06 0.000000
+ 8.680000000000e-06 3.300000
+ 8.689999000000e-06 3.300000
+ 8.690000000000e-06 0.000000
+ 8.699999000000e-06 0.000000
+ 8.700000000000e-06 3.300000
+ 8.709999000000e-06 3.300000
+ 8.710000000000e-06 0.000000
+ 8.719999000000e-06 0.000000
+ 8.720000000000e-06 3.300000
+ 8.729999000000e-06 3.300000
+ 8.730000000000e-06 0.000000
+ 8.739999000000e-06 0.000000
+ 8.740000000000e-06 3.300000
+ 8.749999000000e-06 3.300000
+ 8.750000000000e-06 0.000000
+ 8.759999000000e-06 0.000000
+ 8.760000000000e-06 3.300000
+ 8.769999000000e-06 3.300000
+ 8.770000000000e-06 0.000000
+ 8.779999000000e-06 0.000000
+ 8.780000000000e-06 3.300000
+ 8.789999000000e-06 3.300000
+ 8.790000000000e-06 0.000000
+ 8.799999000000e-06 0.000000
+ 8.800000000000e-06 3.300000
+ 8.809999000000e-06 3.300000
+ 8.810000000000e-06 0.000000
+ 8.819999000000e-06 0.000000
+ 8.820000000000e-06 3.300000
+ 8.829999000000e-06 3.300000
+ 8.830000000000e-06 0.000000
+ 8.839999000000e-06 0.000000
+ 8.840000000000e-06 3.300000
+ 8.849999000000e-06 3.300000
+ 8.850000000000e-06 0.000000
+ 8.859999000000e-06 0.000000
+ 8.860000000000e-06 3.300000
+ 8.869999000000e-06 3.300000
+ 8.870000000000e-06 0.000000
+ 8.879999000000e-06 0.000000
+ 8.880000000000e-06 3.300000
+ 8.889999000000e-06 3.300000
+ 8.890000000000e-06 0.000000
+ 8.899999000000e-06 0.000000
+ 8.900000000000e-06 3.300000
+ 8.909999000000e-06 3.300000
+ 8.910000000000e-06 0.000000
+ 8.919999000000e-06 0.000000
+ 8.920000000000e-06 3.300000
+ 8.929999000000e-06 3.300000
+ 8.930000000000e-06 0.000000
+ 8.939999000000e-06 0.000000
+ 8.940000000000e-06 3.300000
+ 8.949999000000e-06 3.300000
+ 8.950000000000e-06 0.000000
+ 8.959999000000e-06 0.000000
+ 8.960000000000e-06 3.300000
+ 8.969999000000e-06 3.300000
+ 8.970000000000e-06 0.000000
+ 8.979999000000e-06 0.000000
+ 8.980000000000e-06 3.300000
+ 8.989999000000e-06 3.300000
+ 8.990000000000e-06 0.000000
+ 8.999999000000e-06 0.000000
+ 9.000000000000e-06 3.300000
+ 9.009999000000e-06 3.300000
+ 9.010000000000e-06 0.000000
+ 9.019999000000e-06 0.000000
+ 9.020000000000e-06 3.300000
+ 9.029999000000e-06 3.300000
+ 9.030000000000e-06 0.000000
+ 9.039999000000e-06 0.000000
+ 9.040000000000e-06 3.300000
+ 9.049999000000e-06 3.300000
+ 9.050000000000e-06 0.000000
+ 9.059999000000e-06 0.000000
+ 9.060000000000e-06 3.300000
+ 9.069999000000e-06 3.300000
+ 9.070000000000e-06 0.000000
+ 9.079999000000e-06 0.000000
+ 9.080000000000e-06 3.300000
+ 9.089999000000e-06 3.300000
+ 9.090000000000e-06 0.000000
+ 9.099999000000e-06 0.000000
+ 9.100000000000e-06 3.300000
+ 9.109999000000e-06 3.300000
+ 9.110000000000e-06 0.000000
+ 9.119999000000e-06 0.000000
+ 9.120000000000e-06 3.300000
+ 9.129999000000e-06 3.300000
+ 9.130000000000e-06 0.000000
+ 9.139999000000e-06 0.000000
+ 9.140000000000e-06 3.300000
+ 9.149999000000e-06 3.300000
+ 9.150000000000e-06 0.000000
+ 9.159999000000e-06 0.000000
+ 9.160000000000e-06 3.300000
+ 9.169999000000e-06 3.300000
+ 9.170000000000e-06 0.000000
+ 9.179999000000e-06 0.000000
+ 9.180000000000e-06 3.300000
+ 9.189999000000e-06 3.300000
+ 9.190000000000e-06 0.000000
+ 9.199999000000e-06 0.000000
+ 9.200000000000e-06 3.300000
+ 9.209999000000e-06 3.300000
+ 9.210000000000e-06 0.000000
+ 9.219999000000e-06 0.000000
+ 9.220000000000e-06 3.300000
+ 9.229999000000e-06 3.300000
+ 9.230000000000e-06 0.000000
+ 9.239999000000e-06 0.000000
+ 9.240000000000e-06 3.300000
+ 9.249999000000e-06 3.300000
+ 9.250000000000e-06 0.000000
+ 9.259999000000e-06 0.000000
+ 9.260000000000e-06 3.300000
+ 9.269999000000e-06 3.300000
+ 9.270000000000e-06 0.000000
+ 9.279999000000e-06 0.000000
+ 9.280000000000e-06 3.300000
+ 9.289999000000e-06 3.300000
+ 9.290000000000e-06 0.000000
+ 9.299999000000e-06 0.000000
+ 9.300000000000e-06 3.300000
+ 9.309999000000e-06 3.300000
+ 9.310000000000e-06 0.000000
+ 9.319999000000e-06 0.000000
+ 9.320000000000e-06 3.300000
+ 9.329999000000e-06 3.300000
+ 9.330000000000e-06 0.000000
+ 9.339999000000e-06 0.000000
+ 9.340000000000e-06 3.300000
+ 9.349999000000e-06 3.300000
+ 9.350000000000e-06 0.000000
+ 9.359999000000e-06 0.000000
+ 9.360000000000e-06 3.300000
+ 9.369999000000e-06 3.300000
+ 9.370000000000e-06 0.000000
+ 9.379999000000e-06 0.000000
+ 9.380000000000e-06 3.300000
+ 9.389999000000e-06 3.300000
+ 9.390000000000e-06 0.000000
+ 9.399999000000e-06 0.000000
+ 9.400000000000e-06 3.300000
+ 9.409999000000e-06 3.300000
+ 9.410000000000e-06 0.000000
+ 9.419999000000e-06 0.000000
+ 9.420000000000e-06 3.300000
+ 9.429999000000e-06 3.300000
+ 9.430000000000e-06 0.000000
+ 9.439999000000e-06 0.000000
+ 9.440000000000e-06 3.300000
+ 9.449999000000e-06 3.300000
+ 9.450000000000e-06 0.000000
+ 9.459999000000e-06 0.000000
+ 9.460000000000e-06 3.300000
+ 9.469999000000e-06 3.300000
+ 9.470000000000e-06 0.000000
+ 9.479999000000e-06 0.000000
+ 9.480000000000e-06 3.300000
+ 9.489999000000e-06 3.300000
+ 9.490000000000e-06 0.000000
+ 9.499999000000e-06 0.000000
+ 9.500000000000e-06 3.300000
+ 9.509999000000e-06 3.300000
+ 9.510000000000e-06 0.000000
+ 9.519999000000e-06 0.000000
+ 9.520000000000e-06 3.300000
+ 9.529999000000e-06 3.300000
+ 9.530000000000e-06 0.000000
+ 9.539999000000e-06 0.000000
+ 9.540000000000e-06 3.300000
+ 9.549999000000e-06 3.300000
+ 9.550000000000e-06 0.000000
+ 9.559999000000e-06 0.000000
+ 9.560000000000e-06 3.300000
+ 9.569999000000e-06 3.300000
+ 9.570000000000e-06 0.000000
+ 9.579999000000e-06 0.000000
+ 9.580000000000e-06 3.300000
+ 9.589999000000e-06 3.300000
+ 9.590000000000e-06 0.000000
+ 9.599999000000e-06 0.000000
+ 9.600000000000e-06 3.300000
+ 9.609999000000e-06 3.300000
+ 9.610000000000e-06 0.000000
+ 9.619999000000e-06 0.000000
+ 9.620000000000e-06 3.300000
+ 9.629999000000e-06 3.300000
+ 9.630000000000e-06 0.000000
+ 9.639999000000e-06 0.000000
+ 9.640000000000e-06 3.300000
+ 9.649999000000e-06 3.300000
+ 9.650000000000e-06 0.000000
+ 9.659999000000e-06 0.000000
+ 9.660000000000e-06 3.300000
+ 9.669999000000e-06 3.300000
+ 9.670000000000e-06 0.000000
+ 9.679999000000e-06 0.000000
+ 9.680000000000e-06 3.300000
+ 9.689999000000e-06 3.300000
+ 9.690000000000e-06 0.000000
+ 9.699999000000e-06 0.000000
+ 9.700000000000e-06 3.300000
+ 9.709999000000e-06 3.300000
+ 9.710000000000e-06 0.000000
+ 9.719999000000e-06 0.000000
+ 9.720000000000e-06 3.300000
+ 9.729999000000e-06 3.300000
+ 9.730000000000e-06 0.000000
+ 9.739999000000e-06 0.000000
+ 9.740000000000e-06 3.300000
+ 9.749999000000e-06 3.300000
+ 9.750000000000e-06 0.000000
+ 9.759999000000e-06 0.000000
+ 9.760000000000e-06 3.300000
+ 9.769999000000e-06 3.300000
+ 9.770000000000e-06 0.000000
+ 9.779999000000e-06 0.000000
+ 9.780000000000e-06 3.300000
+ 9.789999000000e-06 3.300000
+ 9.790000000000e-06 0.000000
+ 9.799999000000e-06 0.000000
+ 9.800000000000e-06 3.300000
+ 9.809999000000e-06 3.300000
+ 9.810000000000e-06 0.000000
+ 9.819999000000e-06 0.000000
+ 9.820000000000e-06 3.300000
+ 9.829999000000e-06 3.300000
+ 9.830000000000e-06 0.000000
+ 9.839999000000e-06 0.000000
+ 9.840000000000e-06 3.300000
+ 9.849999000000e-06 3.300000
+ 9.850000000000e-06 0.000000
+ 9.859999000000e-06 0.000000
+ 9.860000000000e-06 3.300000
+ 9.869999000000e-06 3.300000
+ 9.870000000000e-06 0.000000
+ 9.879999000000e-06 0.000000
+ 9.880000000000e-06 3.300000
+ 9.889999000000e-06 3.300000
+ 9.890000000000e-06 0.000000
+ 9.899999000000e-06 0.000000
+ 9.900000000000e-06 3.300000
+ 9.909999000000e-06 3.300000
+ 9.910000000000e-06 0.000000
+ 9.919999000000e-06 0.000000
+ 9.920000000000e-06 3.300000
+ 9.929999000000e-06 3.300000
+ 9.930000000000e-06 0.000000
+ 9.939999000000e-06 0.000000
+ 9.940000000000e-06 3.300000
+ 9.949999000000e-06 3.300000
+ 9.950000000000e-06 0.000000
+ 9.959999000000e-06 0.000000
+ 9.960000000000e-06 3.300000
+ 9.969999000000e-06 3.300000
+ 9.970000000000e-06 0.000000
+ 9.979999000000e-06 0.000000
+ 9.980000000000e-06 3.300000
+ 9.989999000000e-06 3.300000
+ 9.990000000000e-06 0.000000
+ 9.999999000000e-06 0.000000
+ 1.000000000000e-05 3.300000
+ 1.000999900000e-05 3.300000
+ 1.001000000000e-05 0.000000
+ 1.001999900000e-05 0.000000
+ 1.002000000000e-05 3.300000
+ 1.002999900000e-05 3.300000
+ 1.003000000000e-05 0.000000
+ 1.003999900000e-05 0.000000
+ 1.004000000000e-05 3.300000
+ 1.004999900000e-05 3.300000
+ 1.005000000000e-05 0.000000
+ 1.005999900000e-05 0.000000
+ 1.006000000000e-05 3.300000
+ 1.006999900000e-05 3.300000
+ 1.007000000000e-05 0.000000
+ 1.007999900000e-05 0.000000
+ 1.008000000000e-05 3.300000
+ 1.008999900000e-05 3.300000
+ 1.009000000000e-05 0.000000
+ 1.009999900000e-05 0.000000
+ 1.010000000000e-05 3.300000
+ 1.010999900000e-05 3.300000
+ 1.011000000000e-05 0.000000
+ 1.011999900000e-05 0.000000
+ 1.012000000000e-05 3.300000
+ 1.012999900000e-05 3.300000
+ 1.013000000000e-05 0.000000
+ 1.013999900000e-05 0.000000
+ 1.014000000000e-05 3.300000
+ 1.014999900000e-05 3.300000
+ 1.015000000000e-05 0.000000
+ 1.015999900000e-05 0.000000
+ 1.016000000000e-05 3.300000
+ 1.016999900000e-05 3.300000
+ 1.017000000000e-05 0.000000
+ 1.017999900000e-05 0.000000
+ 1.018000000000e-05 3.300000
+ 1.018999900000e-05 3.300000
+ 1.019000000000e-05 0.000000
+ 1.019999900000e-05 0.000000
+ 1.020000000000e-05 3.300000
+ 1.020999900000e-05 3.300000
+ 1.021000000000e-05 0.000000
+ 1.021999900000e-05 0.000000
+ 1.022000000000e-05 3.300000
+ 1.022999900000e-05 3.300000
+ 1.023000000000e-05 0.000000
+ 1.023999900000e-05 0.000000
+ 1.024000000000e-05 3.300000
+ 1.024999900000e-05 3.300000
+ 1.025000000000e-05 0.000000
+ 1.025999900000e-05 0.000000
+ 1.026000000000e-05 3.300000
+ 1.026999900000e-05 3.300000
+ 1.027000000000e-05 0.000000
+ 1.027999900000e-05 0.000000
+ 1.028000000000e-05 3.300000
+ 1.028999900000e-05 3.300000
+ 1.029000000000e-05 0.000000
+ 1.029999900000e-05 0.000000
+ 1.030000000000e-05 3.300000
+ 1.030999900000e-05 3.300000
+ 1.031000000000e-05 0.000000
+ 1.031999900000e-05 0.000000
+ 1.032000000000e-05 3.300000
+ 1.032999900000e-05 3.300000
+ 1.033000000000e-05 0.000000
+ 1.033999900000e-05 0.000000
+ 1.034000000000e-05 3.300000
+ 1.034999900000e-05 3.300000
+ 1.035000000000e-05 0.000000
+ 1.035999900000e-05 0.000000
+ 1.036000000000e-05 3.300000
+ 1.036999900000e-05 3.300000
+ 1.037000000000e-05 0.000000
+ 1.037999900000e-05 0.000000
+ 1.038000000000e-05 3.300000
+ 1.038999900000e-05 3.300000
+ 1.039000000000e-05 0.000000
+ 1.039999900000e-05 0.000000
+ 1.040000000000e-05 3.300000
+ 1.040999900000e-05 3.300000
+ 1.041000000000e-05 0.000000
+ 1.041999900000e-05 0.000000
+ 1.042000000000e-05 3.300000
+ 1.042999900000e-05 3.300000
+ 1.043000000000e-05 0.000000
+ 1.043999900000e-05 0.000000
+ 1.044000000000e-05 3.300000
* Signal: rst_n
Vrst_n rst_n 0 PWL(
+ 0.000000000000e+00 0.000000
+ 1.799990000000e-07 0.000000
+ 1.800000000000e-07 3.300000
+ 2.039999000000e-06 3.300000
+ 2.040000000000e-06 0.000000
+ 2.239999000000e-06 0.000000
+ 2.240000000000e-06 3.300000
+ 5.299999000000e-06 3.300000
+ 5.300000000000e-06 0.000000
+ 5.499999000000e-06 0.000000
+ 5.500000000000e-06 3.300000
+ 6.799999000000e-06 3.300000
+ 6.800000000000e-06 0.000000
+ 6.999999000000e-06 0.000000
+ 7.000000000000e-06 3.300000
+ 9.579999000000e-06 3.300000
+ 9.580000000000e-06 0.000000
+ 9.779999000000e-06 0.000000
+ 9.780000000000e-06 3.300000
* Signal: in
Vin in 0 PWL(
+ 0.000000000000e+00 0.000000
+ 1.999990000000e-07 0.000000
+ 2.000000000000e-07 3.300000
+ 3.599990000000e-07 3.300000
+ 3.600000000000e-07 0.000000
+ 5.199990000000e-07 0.000000
+ 5.200000000000e-07 3.300000
+ 6.799990000000e-07 3.300000
+ 6.800000000000e-07 0.000000
+ 8.399990000000e-07 0.000000
+ 8.400000000000e-07 3.300000
+ 9.999990000000e-07 3.300000
+ 1.000000000000e-06 0.000000
+ 1.159999000000e-06 0.000000
+ 1.160000000000e-06 3.300000
+ 1.319999000000e-06 3.300000
+ 1.320000000000e-06 0.000000
+ 1.719999000000e-06 0.000000
+ 1.720000000000e-06 3.300000
+ 2.039999000000e-06 3.300000
+ 2.040000000000e-06 0.000000
+ 2.899999000000e-06 0.000000
+ 2.900000000000e-06 3.300000
+ 4.179999000000e-06 3.300000
+ 4.180000000000e-06 0.000000
+ 4.819999000000e-06 0.000000
+ 4.820000000000e-06 3.300000
+ 4.979999000000e-06 3.300000
+ 4.980000000000e-06 0.000000
+ 5.139999000000e-06 0.000000
+ 5.140000000000e-06 3.300000
+ 5.299999000000e-06 3.300000
+ 5.300000000000e-06 0.000000
+ 5.519999000000e-06 0.000000
+ 5.520000000000e-06 3.300000
+ 5.679999000000e-06 3.300000
+ 5.680000000000e-06 0.000000
+ 5.839999000000e-06 0.000000
+ 5.840000000000e-06 3.300000
+ 6.319999000000e-06 3.300000
+ 6.320000000000e-06 0.000000
+ 8.299999000000e-06 0.000000
+ 8.300000000000e-06 3.300000
+ 9.579999000000e-06 3.300000
+ 9.580000000000e-06 0.000000
+ 9.799999000000e-06 0.000000
+ 9.800000000000e-06 3.300000
+ 1.011999900000e-05 3.300000
+ 1.012000000000e-05 0.000000
+ 1.027999900000e-05 0.000000
+ 1.028000000000e-05 3.300000
* Signal: enable
Venable enable 0 PWL(
+ 0.000000000000e+00 0.000000
+ 1.799990000000e-07 0.000000
+ 1.800000000000e-07 3.300000
+ 1.479999000000e-06 3.300000
+ 1.480000000000e-06 0.000000
+ 1.699999000000e-06 0.000000
+ 1.700000000000e-06 3.300000
+ 2.039999000000e-06 3.300000
+ 2.040000000000e-06 0.000000
+ 2.239999000000e-06 0.000000
+ 2.240000000000e-06 3.300000
+ 5.299999000000e-06 3.300000
+ 5.300000000000e-06 0.000000
+ 5.499999000000e-06 0.000000
+ 5.500000000000e-06 3.300000
+ 6.799999000000e-06 3.300000
+ 6.800000000000e-06 0.000000
+ 6.999999000000e-06 0.000000
+ 7.000000000000e-06 3.300000
+ 9.579999000000e-06 3.300000
+ 9.580000000000e-06 0.000000
+ 9.779999000000e-06 0.000000
+ 9.780000000000e-06 3.300000
