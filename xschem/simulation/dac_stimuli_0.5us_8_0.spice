* Automatically generated 8-bit DAC stimuli
* Code sweep: 0 to 255
* B inputs are binary; T inputs are thermometer encoded

V1 B_R[0] GND PWL(0 0 4.99e-07 0 5e-07 1.8 9.99e-07 1.8 1e-06 0 1.499e-06 0 1.5e-06 1.8 1.999e-06 1.8 2e-06 0 2.499e-06 0 2.5e-06 1.8 2.999e-06 1.8 3e-06 0 3.499e-06 0 3.5e-06 1.8 3.999e-06 1.8 4e-06 0 4.499e-06 0 4.5e-06 1.8 4.999e-06 1.8 5e-06 0 5.499e-06 0 5.5e-06 1.8 5.999e-06 1.8 6e-06 0 6.499e-06 0 6.5e-06 1.8 6.999e-06 1.8 7e-06 0 7.499e-06 0 7.5e-06 1.8 7.999e-06 1.8 8e-06 0 8.499e-06 0 8.5e-06 1.8 8.999e-06 1.8 9e-06 0 9.499e-06 0 9.5e-06 1.8 9.999e-06 1.8 1e-05 0 1.0499e-05 0 1.05e-05 1.8 1.0999e-05 1.8 1.1e-05 0 1.1499e-05 0 1.15e-05 1.8 1.1999e-05 1.8 1.2e-05 0 1.2499e-05 0 1.25e-05 1.8 1.2999e-05 1.8 1.3e-05 0 1.3499e-05 0 1.35e-05 1.8 1.3999e-05 1.8 1.4e-05 0 1.4499e-05 0 1.45e-05 1.8 1.4999e-05 1.8 1.5e-05 0 1.5499e-05 0 1.55e-05 1.8 1.5999e-05 1.8 1.6e-05 0 1.6499e-05 0 1.65e-05 1.8 1.6999e-05 1.8 1.7e-05 0 1.7499e-05 0 1.75e-05 1.8 1.7999e-05 1.8 1.8e-05 0 1.8499e-05 0 1.85e-05 1.8 1.8999e-05 1.8 1.9e-05 0 1.9499e-05 0 1.95e-05 1.8 1.9999e-05 1.8 2e-05 0 2.0499e-05 0 2.05e-05 1.8 2.0999e-05 1.8 2.1e-05 0 2.1499e-05 0 2.15e-05 1.8 2.1999e-05 1.8 2.2e-05 0 2.2499e-05 0 2.25e-05 1.8 2.2999e-05 1.8 2.3e-05 0 2.3499e-05 0 2.35e-05 1.8 2.3999e-05 1.8 2.4e-05 0 2.4499e-05 0 2.45e-05 1.8 2.4999e-05 1.8 2.5e-05 0 2.5499e-05 0 2.55e-05 1.8 2.5999e-05 1.8 2.6e-05 0 2.6499e-05 0 2.65e-05 1.8 2.6999e-05 1.8 2.7e-05 0 2.7499e-05 0 2.75e-05 1.8 2.7999e-05 1.8 2.8e-05 0 2.8499e-05 0 2.85e-05 1.8 2.8999e-05 1.8 2.9e-05 0 2.9499e-05 0 2.95e-05 1.8 2.9999e-05 1.8 3e-05 0 3.0499e-05 0 3.05e-05 1.8 3.0999e-05 1.8 3.1e-05 0 3.1499e-05 0 3.15e-05 1.8 3.1999e-05 1.8 3.2e-05 0 3.2499e-05 0 3.25e-05 1.8 3.2999e-05 1.8 3.3e-05 0 3.3499e-05 0 3.35e-05 1.8 3.3999e-05 1.8 3.4e-05 0 3.4499e-05 0 3.45e-05 1.8 3.4999e-05 1.8 3.5e-05 0 3.5499e-05 0 3.55e-05 1.8 3.5999e-05 1.8 3.6e-05 0 3.6499e-05 0 3.65e-05 1.8 3.6999e-05 1.8 3.7e-05 0 3.7499e-05 0 3.75e-05 1.8 3.7999e-05 1.8 3.8e-05 0 3.8499e-05 0 3.85e-05 1.8 3.8999e-05 1.8 3.9e-05 0 3.9499e-05 0 3.95e-05 1.8 3.9999e-05 1.8 4e-05 0 4.0499e-05 0 4.05e-05 1.8 4.0999e-05 1.8 4.1e-05 0 4.1499e-05 0 4.15e-05 1.8 4.1999e-05 1.8 4.2e-05 0 4.2499e-05 0 4.25e-05 1.8 4.2999e-05 1.8 4.3e-05 0 4.3499e-05 0 4.35e-05 1.8 4.3999e-05 1.8 4.4e-05 0 4.4499e-05 0 4.45e-05 1.8 4.4999e-05 1.8 4.5e-05 0 4.5499e-05 0 4.55e-05 1.8 4.5999e-05 1.8 4.6e-05 0 4.6499e-05 0 4.65e-05 1.8 4.6999e-05 1.8 4.7e-05 0 4.7499e-05 0 4.75e-05 1.8 4.7999e-05 1.8 4.8e-05 0 4.8499e-05 0 4.85e-05 1.8 4.8999e-05 1.8 4.9e-05 0 4.9499e-05 0 4.95e-05 1.8 4.9999e-05 1.8 5e-05 0 5.0499e-05 0 5.05e-05 1.8 5.0999e-05 1.8 5.1e-05 0 5.1499e-05 0 5.15e-05 1.8 5.1999e-05 1.8 5.2e-05 0 5.2499e-05 0 5.25e-05 1.8 5.2999e-05 1.8 5.3e-05 0 5.3499e-05 0 5.35e-05 1.8 5.3999e-05 1.8 5.4e-05 0 5.4499e-05 0 5.45e-05 1.8 5.4999e-05 1.8 5.5e-05 0 5.5499e-05 0 5.55e-05 1.8 5.5999e-05 1.8 5.6e-05 0 5.6499e-05 0 5.65e-05 1.8 5.6999e-05 1.8 5.7e-05 0 5.7499e-05 0 5.75e-05 1.8 5.7999e-05 1.8 5.8e-05 0 5.8499e-05 0 5.85e-05 1.8 5.8999e-05 1.8 5.9e-05 0 5.9499e-05 0 5.95e-05 1.8 5.9999e-05 1.8 6e-05 0 6.0499e-05 0 6.05e-05 1.8 6.0999e-05 1.8 6.1e-05 0 6.1499e-05 0 6.15e-05 1.8 6.1999e-05 1.8 6.2e-05 0 6.2499e-05 0 6.25e-05 1.8 6.2999e-05 1.8 6.3e-05 0 6.3499e-05 0 6.35e-05 1.8 6.3999e-05 1.8 6.4e-05 0 6.4499e-05 0 6.45e-05 1.8 6.4999e-05 1.8 6.5e-05 0 6.5499e-05 0 6.55e-05 1.8 6.5999e-05 1.8 6.6e-05 0 6.6499e-05 0 6.65e-05 1.8 6.6999e-05 1.8 6.7e-05 0 6.7499e-05 0 6.75e-05 1.8 6.7999e-05 1.8 6.8e-05 0 6.8499e-05 0 6.85e-05 1.8 6.8999e-05 1.8 6.9e-05 0 6.9499e-05 0 6.95e-05 1.8 6.9999e-05 1.8 7e-05 0 7.0499e-05 0 7.05e-05 1.8 7.0999e-05 1.8 7.1e-05 0 7.1499e-05 0 7.15e-05 1.8 7.1999e-05 1.8 7.2e-05 0 7.2499e-05 0 7.25e-05 1.8 7.2999e-05 1.8 7.3e-05 0 7.3499e-05 0 7.35e-05 1.8 7.3999e-05 1.8 7.4e-05 0 7.4499e-05 0 7.45e-05 1.8 7.4999e-05 1.8 7.5e-05 0 7.5499e-05 0 7.55e-05 1.8 7.5999e-05 1.8 7.6e-05 0 7.6499e-05 0 7.65e-05 1.8 7.6999e-05 1.8 7.7e-05 0 7.7499e-05 0 7.75e-05 1.8 7.7999e-05 1.8 7.8e-05 0 7.8499e-05 0 7.85e-05 1.8 7.8999e-05 1.8 7.9e-05 0 7.9499e-05 0 7.95e-05 1.8 7.9999e-05 1.8 8e-05 0 8.0499e-05 0 8.05e-05 1.8 8.0999e-05 1.8 8.1e-05 0 8.1499e-05 0 8.15e-05 1.8 8.1999e-05 1.8 8.2e-05 0 8.2499e-05 0 8.25e-05 1.8 8.2999e-05 1.8 8.3e-05 0 8.3499e-05 0 8.35e-05 1.8 8.3999e-05 1.8 8.4e-05 0 8.4499e-05 0 8.45e-05 1.8 8.4999e-05 1.8 8.5e-05 0 8.5499e-05 0 8.55e-05 1.8 8.5999e-05 1.8 8.6e-05 0 8.6499e-05 0 8.65e-05 1.8 8.6999e-05 1.8 8.7e-05 0 8.7499e-05 0 8.75e-05 1.8 8.7999e-05 1.8 8.8e-05 0 8.8499e-05 0 8.85e-05 1.8 8.8999e-05 1.8 8.9e-05 0 8.9499e-05 0 8.95e-05 1.8 8.9999e-05 1.8 9e-05 0 9.0499e-05 0 9.05e-05 1.8 9.0999e-05 1.8 9.1e-05 0 9.1499e-05 0 9.15e-05 1.8 9.1999e-05 1.8 9.2e-05 0 9.2499e-05 0 9.25e-05 1.8 9.2999e-05 1.8 9.3e-05 0 9.3499e-05 0 9.35e-05 1.8 9.3999e-05 1.8 9.4e-05 0 9.4499e-05 0 9.45e-05 1.8 9.4999e-05 1.8 9.5e-05 0 9.5499e-05 0 9.55e-05 1.8 9.5999e-05 1.8 9.6e-05 0 9.6499e-05 0 9.65e-05 1.8 9.6999e-05 1.8 9.7e-05 0 9.7499e-05 0 9.75e-05 1.8 9.7999e-05 1.8 9.8e-05 0 9.8499e-05 0 9.85e-05 1.8 9.8999e-05 1.8 9.9e-05 0 9.9499e-05 0 9.95e-05 1.8 9.9999e-05 1.8 0.0001 0 0.000100499 0 0.0001005 1.8 0.000100999 1.8 0.000101 0 0.000101499 0 0.0001015 1.8 0.000101999 1.8 0.000102 0 0.000102499 0 0.0001025 1.8 0.000102999 1.8 0.000103 0 0.000103499 0 0.0001035 1.8 0.000103999 1.8 0.000104 0 0.000104499 0 0.0001045 1.8 0.000104999 1.8 0.000105 0 0.000105499 0 0.0001055 1.8 0.000105999 1.8 0.000106 0 0.000106499 0 0.0001065 1.8 0.000106999 1.8 0.000107 0 0.000107499 0 0.0001075 1.8 0.000107999 1.8 0.000108 0 0.000108499 0 0.0001085 1.8 0.000108999 1.8 0.000109 0 0.000109499 0 0.0001095 1.8 0.000109999 1.8 0.00011 0 0.000110499 0 0.0001105 1.8 0.000110999 1.8 0.000111 0 0.000111499 0 0.0001115 1.8 0.000111999 1.8 0.000112 0 0.000112499 0 0.0001125 1.8 0.000112999 1.8 0.000113 0 0.000113499 0 0.0001135 1.8 0.000113999 1.8 0.000114 0 0.000114499 0 0.0001145 1.8 0.000114999 1.8 0.000115 0 0.000115499 0 0.0001155 1.8 0.000115999 1.8 0.000116 0 0.000116499 0 0.0001165 1.8 0.000116999 1.8 0.000117 0 0.000117499 0 0.0001175 1.8 0.000117999 1.8 0.000118 0 0.000118499 0 0.0001185 1.8 0.000118999 1.8 0.000119 0 0.000119499 0 0.0001195 1.8 0.000119999 1.8 0.00012 0 0.000120499 0 0.0001205 1.8 0.000120999 1.8 0.000121 0 0.000121499 0 0.0001215 1.8 0.000121999 1.8 0.000122 0 0.000122499 0 0.0001225 1.8 0.000122999 1.8 0.000123 0 0.000123499 0 0.0001235 1.8 0.000123999 1.8 0.000124 0 0.000124499 0 0.0001245 1.8 0.000124999 1.8 0.000125 0 0.000125499 0 0.0001255 1.8 0.000125999 1.8 0.000126 0 0.000126499 0 0.0001265 1.8 0.000126999 1.8 0.000127 0 0.000127499 0 0.0001275 1.8 0.000128 1.8)
V2 B_R[1] GND PWL(0 0 4.99e-07 0 5e-07 0 9.99e-07 0 1e-06 1.8 1.499e-06 1.8 1.5e-06 1.8 1.999e-06 1.8 2e-06 0 2.499e-06 0 2.5e-06 0 2.999e-06 0 3e-06 1.8 3.499e-06 1.8 3.5e-06 1.8 3.999e-06 1.8 4e-06 0 4.499e-06 0 4.5e-06 0 4.999e-06 0 5e-06 1.8 5.499e-06 1.8 5.5e-06 1.8 5.999e-06 1.8 6e-06 0 6.499e-06 0 6.5e-06 0 6.999e-06 0 7e-06 1.8 7.499e-06 1.8 7.5e-06 1.8 7.999e-06 1.8 8e-06 0 8.499e-06 0 8.5e-06 0 8.999e-06 0 9e-06 1.8 9.499e-06 1.8 9.5e-06 1.8 9.999e-06 1.8 1e-05 0 1.0499e-05 0 1.05e-05 0 1.0999e-05 0 1.1e-05 1.8 1.1499e-05 1.8 1.15e-05 1.8 1.1999e-05 1.8 1.2e-05 0 1.2499e-05 0 1.25e-05 0 1.2999e-05 0 1.3e-05 1.8 1.3499e-05 1.8 1.35e-05 1.8 1.3999e-05 1.8 1.4e-05 0 1.4499e-05 0 1.45e-05 0 1.4999e-05 0 1.5e-05 1.8 1.5499e-05 1.8 1.55e-05 1.8 1.5999e-05 1.8 1.6e-05 0 1.6499e-05 0 1.65e-05 0 1.6999e-05 0 1.7e-05 1.8 1.7499e-05 1.8 1.75e-05 1.8 1.7999e-05 1.8 1.8e-05 0 1.8499e-05 0 1.85e-05 0 1.8999e-05 0 1.9e-05 1.8 1.9499e-05 1.8 1.95e-05 1.8 1.9999e-05 1.8 2e-05 0 2.0499e-05 0 2.05e-05 0 2.0999e-05 0 2.1e-05 1.8 2.1499e-05 1.8 2.15e-05 1.8 2.1999e-05 1.8 2.2e-05 0 2.2499e-05 0 2.25e-05 0 2.2999e-05 0 2.3e-05 1.8 2.3499e-05 1.8 2.35e-05 1.8 2.3999e-05 1.8 2.4e-05 0 2.4499e-05 0 2.45e-05 0 2.4999e-05 0 2.5e-05 1.8 2.5499e-05 1.8 2.55e-05 1.8 2.5999e-05 1.8 2.6e-05 0 2.6499e-05 0 2.65e-05 0 2.6999e-05 0 2.7e-05 1.8 2.7499e-05 1.8 2.75e-05 1.8 2.7999e-05 1.8 2.8e-05 0 2.8499e-05 0 2.85e-05 0 2.8999e-05 0 2.9e-05 1.8 2.9499e-05 1.8 2.95e-05 1.8 2.9999e-05 1.8 3e-05 0 3.0499e-05 0 3.05e-05 0 3.0999e-05 0 3.1e-05 1.8 3.1499e-05 1.8 3.15e-05 1.8 3.1999e-05 1.8 3.2e-05 0 3.2499e-05 0 3.25e-05 0 3.2999e-05 0 3.3e-05 1.8 3.3499e-05 1.8 3.35e-05 1.8 3.3999e-05 1.8 3.4e-05 0 3.4499e-05 0 3.45e-05 0 3.4999e-05 0 3.5e-05 1.8 3.5499e-05 1.8 3.55e-05 1.8 3.5999e-05 1.8 3.6e-05 0 3.6499e-05 0 3.65e-05 0 3.6999e-05 0 3.7e-05 1.8 3.7499e-05 1.8 3.75e-05 1.8 3.7999e-05 1.8 3.8e-05 0 3.8499e-05 0 3.85e-05 0 3.8999e-05 0 3.9e-05 1.8 3.9499e-05 1.8 3.95e-05 1.8 3.9999e-05 1.8 4e-05 0 4.0499e-05 0 4.05e-05 0 4.0999e-05 0 4.1e-05 1.8 4.1499e-05 1.8 4.15e-05 1.8 4.1999e-05 1.8 4.2e-05 0 4.2499e-05 0 4.25e-05 0 4.2999e-05 0 4.3e-05 1.8 4.3499e-05 1.8 4.35e-05 1.8 4.3999e-05 1.8 4.4e-05 0 4.4499e-05 0 4.45e-05 0 4.4999e-05 0 4.5e-05 1.8 4.5499e-05 1.8 4.55e-05 1.8 4.5999e-05 1.8 4.6e-05 0 4.6499e-05 0 4.65e-05 0 4.6999e-05 0 4.7e-05 1.8 4.7499e-05 1.8 4.75e-05 1.8 4.7999e-05 1.8 4.8e-05 0 4.8499e-05 0 4.85e-05 0 4.8999e-05 0 4.9e-05 1.8 4.9499e-05 1.8 4.95e-05 1.8 4.9999e-05 1.8 5e-05 0 5.0499e-05 0 5.05e-05 0 5.0999e-05 0 5.1e-05 1.8 5.1499e-05 1.8 5.15e-05 1.8 5.1999e-05 1.8 5.2e-05 0 5.2499e-05 0 5.25e-05 0 5.2999e-05 0 5.3e-05 1.8 5.3499e-05 1.8 5.35e-05 1.8 5.3999e-05 1.8 5.4e-05 0 5.4499e-05 0 5.45e-05 0 5.4999e-05 0 5.5e-05 1.8 5.5499e-05 1.8 5.55e-05 1.8 5.5999e-05 1.8 5.6e-05 0 5.6499e-05 0 5.65e-05 0 5.6999e-05 0 5.7e-05 1.8 5.7499e-05 1.8 5.75e-05 1.8 5.7999e-05 1.8 5.8e-05 0 5.8499e-05 0 5.85e-05 0 5.8999e-05 0 5.9e-05 1.8 5.9499e-05 1.8 5.95e-05 1.8 5.9999e-05 1.8 6e-05 0 6.0499e-05 0 6.05e-05 0 6.0999e-05 0 6.1e-05 1.8 6.1499e-05 1.8 6.15e-05 1.8 6.1999e-05 1.8 6.2e-05 0 6.2499e-05 0 6.25e-05 0 6.2999e-05 0 6.3e-05 1.8 6.3499e-05 1.8 6.35e-05 1.8 6.3999e-05 1.8 6.4e-05 0 6.4499e-05 0 6.45e-05 0 6.4999e-05 0 6.5e-05 1.8 6.5499e-05 1.8 6.55e-05 1.8 6.5999e-05 1.8 6.6e-05 0 6.6499e-05 0 6.65e-05 0 6.6999e-05 0 6.7e-05 1.8 6.7499e-05 1.8 6.75e-05 1.8 6.7999e-05 1.8 6.8e-05 0 6.8499e-05 0 6.85e-05 0 6.8999e-05 0 6.9e-05 1.8 6.9499e-05 1.8 6.95e-05 1.8 6.9999e-05 1.8 7e-05 0 7.0499e-05 0 7.05e-05 0 7.0999e-05 0 7.1e-05 1.8 7.1499e-05 1.8 7.15e-05 1.8 7.1999e-05 1.8 7.2e-05 0 7.2499e-05 0 7.25e-05 0 7.2999e-05 0 7.3e-05 1.8 7.3499e-05 1.8 7.35e-05 1.8 7.3999e-05 1.8 7.4e-05 0 7.4499e-05 0 7.45e-05 0 7.4999e-05 0 7.5e-05 1.8 7.5499e-05 1.8 7.55e-05 1.8 7.5999e-05 1.8 7.6e-05 0 7.6499e-05 0 7.65e-05 0 7.6999e-05 0 7.7e-05 1.8 7.7499e-05 1.8 7.75e-05 1.8 7.7999e-05 1.8 7.8e-05 0 7.8499e-05 0 7.85e-05 0 7.8999e-05 0 7.9e-05 1.8 7.9499e-05 1.8 7.95e-05 1.8 7.9999e-05 1.8 8e-05 0 8.0499e-05 0 8.05e-05 0 8.0999e-05 0 8.1e-05 1.8 8.1499e-05 1.8 8.15e-05 1.8 8.1999e-05 1.8 8.2e-05 0 8.2499e-05 0 8.25e-05 0 8.2999e-05 0 8.3e-05 1.8 8.3499e-05 1.8 8.35e-05 1.8 8.3999e-05 1.8 8.4e-05 0 8.4499e-05 0 8.45e-05 0 8.4999e-05 0 8.5e-05 1.8 8.5499e-05 1.8 8.55e-05 1.8 8.5999e-05 1.8 8.6e-05 0 8.6499e-05 0 8.65e-05 0 8.6999e-05 0 8.7e-05 1.8 8.7499e-05 1.8 8.75e-05 1.8 8.7999e-05 1.8 8.8e-05 0 8.8499e-05 0 8.85e-05 0 8.8999e-05 0 8.9e-05 1.8 8.9499e-05 1.8 8.95e-05 1.8 8.9999e-05 1.8 9e-05 0 9.0499e-05 0 9.05e-05 0 9.0999e-05 0 9.1e-05 1.8 9.1499e-05 1.8 9.15e-05 1.8 9.1999e-05 1.8 9.2e-05 0 9.2499e-05 0 9.25e-05 0 9.2999e-05 0 9.3e-05 1.8 9.3499e-05 1.8 9.35e-05 1.8 9.3999e-05 1.8 9.4e-05 0 9.4499e-05 0 9.45e-05 0 9.4999e-05 0 9.5e-05 1.8 9.5499e-05 1.8 9.55e-05 1.8 9.5999e-05 1.8 9.6e-05 0 9.6499e-05 0 9.65e-05 0 9.6999e-05 0 9.7e-05 1.8 9.7499e-05 1.8 9.75e-05 1.8 9.7999e-05 1.8 9.8e-05 0 9.8499e-05 0 9.85e-05 0 9.8999e-05 0 9.9e-05 1.8 9.9499e-05 1.8 9.95e-05 1.8 9.9999e-05 1.8 0.0001 0 0.000100499 0 0.0001005 0 0.000100999 0 0.000101 1.8 0.000101499 1.8 0.0001015 1.8 0.000101999 1.8 0.000102 0 0.000102499 0 0.0001025 0 0.000102999 0 0.000103 1.8 0.000103499 1.8 0.0001035 1.8 0.000103999 1.8 0.000104 0 0.000104499 0 0.0001045 0 0.000104999 0 0.000105 1.8 0.000105499 1.8 0.0001055 1.8 0.000105999 1.8 0.000106 0 0.000106499 0 0.0001065 0 0.000106999 0 0.000107 1.8 0.000107499 1.8 0.0001075 1.8 0.000107999 1.8 0.000108 0 0.000108499 0 0.0001085 0 0.000108999 0 0.000109 1.8 0.000109499 1.8 0.0001095 1.8 0.000109999 1.8 0.00011 0 0.000110499 0 0.0001105 0 0.000110999 0 0.000111 1.8 0.000111499 1.8 0.0001115 1.8 0.000111999 1.8 0.000112 0 0.000112499 0 0.0001125 0 0.000112999 0 0.000113 1.8 0.000113499 1.8 0.0001135 1.8 0.000113999 1.8 0.000114 0 0.000114499 0 0.0001145 0 0.000114999 0 0.000115 1.8 0.000115499 1.8 0.0001155 1.8 0.000115999 1.8 0.000116 0 0.000116499 0 0.0001165 0 0.000116999 0 0.000117 1.8 0.000117499 1.8 0.0001175 1.8 0.000117999 1.8 0.000118 0 0.000118499 0 0.0001185 0 0.000118999 0 0.000119 1.8 0.000119499 1.8 0.0001195 1.8 0.000119999 1.8 0.00012 0 0.000120499 0 0.0001205 0 0.000120999 0 0.000121 1.8 0.000121499 1.8 0.0001215 1.8 0.000121999 1.8 0.000122 0 0.000122499 0 0.0001225 0 0.000122999 0 0.000123 1.8 0.000123499 1.8 0.0001235 1.8 0.000123999 1.8 0.000124 0 0.000124499 0 0.0001245 0 0.000124999 0 0.000125 1.8 0.000125499 1.8 0.0001255 1.8 0.000125999 1.8 0.000126 0 0.000126499 0 0.0001265 0 0.000126999 0 0.000127 1.8 0.000127499 1.8 0.0001275 1.8 0.000128 1.8)
V3 B_R[2] GND PWL(0 0 4.99e-07 0 5e-07 0 9.99e-07 0 1e-06 0 1.499e-06 0 1.5e-06 0 1.999e-06 0 2e-06 1.8 2.499e-06 1.8 2.5e-06 1.8 2.999e-06 1.8 3e-06 1.8 3.499e-06 1.8 3.5e-06 1.8 3.999e-06 1.8 4e-06 0 4.499e-06 0 4.5e-06 0 4.999e-06 0 5e-06 0 5.499e-06 0 5.5e-06 0 5.999e-06 0 6e-06 1.8 6.499e-06 1.8 6.5e-06 1.8 6.999e-06 1.8 7e-06 1.8 7.499e-06 1.8 7.5e-06 1.8 7.999e-06 1.8 8e-06 0 8.499e-06 0 8.5e-06 0 8.999e-06 0 9e-06 0 9.499e-06 0 9.5e-06 0 9.999e-06 0 1e-05 1.8 1.0499e-05 1.8 1.05e-05 1.8 1.0999e-05 1.8 1.1e-05 1.8 1.1499e-05 1.8 1.15e-05 1.8 1.1999e-05 1.8 1.2e-05 0 1.2499e-05 0 1.25e-05 0 1.2999e-05 0 1.3e-05 0 1.3499e-05 0 1.35e-05 0 1.3999e-05 0 1.4e-05 1.8 1.4499e-05 1.8 1.45e-05 1.8 1.4999e-05 1.8 1.5e-05 1.8 1.5499e-05 1.8 1.55e-05 1.8 1.5999e-05 1.8 1.6e-05 0 1.6499e-05 0 1.65e-05 0 1.6999e-05 0 1.7e-05 0 1.7499e-05 0 1.75e-05 0 1.7999e-05 0 1.8e-05 1.8 1.8499e-05 1.8 1.85e-05 1.8 1.8999e-05 1.8 1.9e-05 1.8 1.9499e-05 1.8 1.95e-05 1.8 1.9999e-05 1.8 2e-05 0 2.0499e-05 0 2.05e-05 0 2.0999e-05 0 2.1e-05 0 2.1499e-05 0 2.15e-05 0 2.1999e-05 0 2.2e-05 1.8 2.2499e-05 1.8 2.25e-05 1.8 2.2999e-05 1.8 2.3e-05 1.8 2.3499e-05 1.8 2.35e-05 1.8 2.3999e-05 1.8 2.4e-05 0 2.4499e-05 0 2.45e-05 0 2.4999e-05 0 2.5e-05 0 2.5499e-05 0 2.55e-05 0 2.5999e-05 0 2.6e-05 1.8 2.6499e-05 1.8 2.65e-05 1.8 2.6999e-05 1.8 2.7e-05 1.8 2.7499e-05 1.8 2.75e-05 1.8 2.7999e-05 1.8 2.8e-05 0 2.8499e-05 0 2.85e-05 0 2.8999e-05 0 2.9e-05 0 2.9499e-05 0 2.95e-05 0 2.9999e-05 0 3e-05 1.8 3.0499e-05 1.8 3.05e-05 1.8 3.0999e-05 1.8 3.1e-05 1.8 3.1499e-05 1.8 3.15e-05 1.8 3.1999e-05 1.8 3.2e-05 0 3.2499e-05 0 3.25e-05 0 3.2999e-05 0 3.3e-05 0 3.3499e-05 0 3.35e-05 0 3.3999e-05 0 3.4e-05 1.8 3.4499e-05 1.8 3.45e-05 1.8 3.4999e-05 1.8 3.5e-05 1.8 3.5499e-05 1.8 3.55e-05 1.8 3.5999e-05 1.8 3.6e-05 0 3.6499e-05 0 3.65e-05 0 3.6999e-05 0 3.7e-05 0 3.7499e-05 0 3.75e-05 0 3.7999e-05 0 3.8e-05 1.8 3.8499e-05 1.8 3.85e-05 1.8 3.8999e-05 1.8 3.9e-05 1.8 3.9499e-05 1.8 3.95e-05 1.8 3.9999e-05 1.8 4e-05 0 4.0499e-05 0 4.05e-05 0 4.0999e-05 0 4.1e-05 0 4.1499e-05 0 4.15e-05 0 4.1999e-05 0 4.2e-05 1.8 4.2499e-05 1.8 4.25e-05 1.8 4.2999e-05 1.8 4.3e-05 1.8 4.3499e-05 1.8 4.35e-05 1.8 4.3999e-05 1.8 4.4e-05 0 4.4499e-05 0 4.45e-05 0 4.4999e-05 0 4.5e-05 0 4.5499e-05 0 4.55e-05 0 4.5999e-05 0 4.6e-05 1.8 4.6499e-05 1.8 4.65e-05 1.8 4.6999e-05 1.8 4.7e-05 1.8 4.7499e-05 1.8 4.75e-05 1.8 4.7999e-05 1.8 4.8e-05 0 4.8499e-05 0 4.85e-05 0 4.8999e-05 0 4.9e-05 0 4.9499e-05 0 4.95e-05 0 4.9999e-05 0 5e-05 1.8 5.0499e-05 1.8 5.05e-05 1.8 5.0999e-05 1.8 5.1e-05 1.8 5.1499e-05 1.8 5.15e-05 1.8 5.1999e-05 1.8 5.2e-05 0 5.2499e-05 0 5.25e-05 0 5.2999e-05 0 5.3e-05 0 5.3499e-05 0 5.35e-05 0 5.3999e-05 0 5.4e-05 1.8 5.4499e-05 1.8 5.45e-05 1.8 5.4999e-05 1.8 5.5e-05 1.8 5.5499e-05 1.8 5.55e-05 1.8 5.5999e-05 1.8 5.6e-05 0 5.6499e-05 0 5.65e-05 0 5.6999e-05 0 5.7e-05 0 5.7499e-05 0 5.75e-05 0 5.7999e-05 0 5.8e-05 1.8 5.8499e-05 1.8 5.85e-05 1.8 5.8999e-05 1.8 5.9e-05 1.8 5.9499e-05 1.8 5.95e-05 1.8 5.9999e-05 1.8 6e-05 0 6.0499e-05 0 6.05e-05 0 6.0999e-05 0 6.1e-05 0 6.1499e-05 0 6.15e-05 0 6.1999e-05 0 6.2e-05 1.8 6.2499e-05 1.8 6.25e-05 1.8 6.2999e-05 1.8 6.3e-05 1.8 6.3499e-05 1.8 6.35e-05 1.8 6.3999e-05 1.8 6.4e-05 0 6.4499e-05 0 6.45e-05 0 6.4999e-05 0 6.5e-05 0 6.5499e-05 0 6.55e-05 0 6.5999e-05 0 6.6e-05 1.8 6.6499e-05 1.8 6.65e-05 1.8 6.6999e-05 1.8 6.7e-05 1.8 6.7499e-05 1.8 6.75e-05 1.8 6.7999e-05 1.8 6.8e-05 0 6.8499e-05 0 6.85e-05 0 6.8999e-05 0 6.9e-05 0 6.9499e-05 0 6.95e-05 0 6.9999e-05 0 7e-05 1.8 7.0499e-05 1.8 7.05e-05 1.8 7.0999e-05 1.8 7.1e-05 1.8 7.1499e-05 1.8 7.15e-05 1.8 7.1999e-05 1.8 7.2e-05 0 7.2499e-05 0 7.25e-05 0 7.2999e-05 0 7.3e-05 0 7.3499e-05 0 7.35e-05 0 7.3999e-05 0 7.4e-05 1.8 7.4499e-05 1.8 7.45e-05 1.8 7.4999e-05 1.8 7.5e-05 1.8 7.5499e-05 1.8 7.55e-05 1.8 7.5999e-05 1.8 7.6e-05 0 7.6499e-05 0 7.65e-05 0 7.6999e-05 0 7.7e-05 0 7.7499e-05 0 7.75e-05 0 7.7999e-05 0 7.8e-05 1.8 7.8499e-05 1.8 7.85e-05 1.8 7.8999e-05 1.8 7.9e-05 1.8 7.9499e-05 1.8 7.95e-05 1.8 7.9999e-05 1.8 8e-05 0 8.0499e-05 0 8.05e-05 0 8.0999e-05 0 8.1e-05 0 8.1499e-05 0 8.15e-05 0 8.1999e-05 0 8.2e-05 1.8 8.2499e-05 1.8 8.25e-05 1.8 8.2999e-05 1.8 8.3e-05 1.8 8.3499e-05 1.8 8.35e-05 1.8 8.3999e-05 1.8 8.4e-05 0 8.4499e-05 0 8.45e-05 0 8.4999e-05 0 8.5e-05 0 8.5499e-05 0 8.55e-05 0 8.5999e-05 0 8.6e-05 1.8 8.6499e-05 1.8 8.65e-05 1.8 8.6999e-05 1.8 8.7e-05 1.8 8.7499e-05 1.8 8.75e-05 1.8 8.7999e-05 1.8 8.8e-05 0 8.8499e-05 0 8.85e-05 0 8.8999e-05 0 8.9e-05 0 8.9499e-05 0 8.95e-05 0 8.9999e-05 0 9e-05 1.8 9.0499e-05 1.8 9.05e-05 1.8 9.0999e-05 1.8 9.1e-05 1.8 9.1499e-05 1.8 9.15e-05 1.8 9.1999e-05 1.8 9.2e-05 0 9.2499e-05 0 9.25e-05 0 9.2999e-05 0 9.3e-05 0 9.3499e-05 0 9.35e-05 0 9.3999e-05 0 9.4e-05 1.8 9.4499e-05 1.8 9.45e-05 1.8 9.4999e-05 1.8 9.5e-05 1.8 9.5499e-05 1.8 9.55e-05 1.8 9.5999e-05 1.8 9.6e-05 0 9.6499e-05 0 9.65e-05 0 9.6999e-05 0 9.7e-05 0 9.7499e-05 0 9.75e-05 0 9.7999e-05 0 9.8e-05 1.8 9.8499e-05 1.8 9.85e-05 1.8 9.8999e-05 1.8 9.9e-05 1.8 9.9499e-05 1.8 9.95e-05 1.8 9.9999e-05 1.8 0.0001 0 0.000100499 0 0.0001005 0 0.000100999 0 0.000101 0 0.000101499 0 0.0001015 0 0.000101999 0 0.000102 1.8 0.000102499 1.8 0.0001025 1.8 0.000102999 1.8 0.000103 1.8 0.000103499 1.8 0.0001035 1.8 0.000103999 1.8 0.000104 0 0.000104499 0 0.0001045 0 0.000104999 0 0.000105 0 0.000105499 0 0.0001055 0 0.000105999 0 0.000106 1.8 0.000106499 1.8 0.0001065 1.8 0.000106999 1.8 0.000107 1.8 0.000107499 1.8 0.0001075 1.8 0.000107999 1.8 0.000108 0 0.000108499 0 0.0001085 0 0.000108999 0 0.000109 0 0.000109499 0 0.0001095 0 0.000109999 0 0.00011 1.8 0.000110499 1.8 0.0001105 1.8 0.000110999 1.8 0.000111 1.8 0.000111499 1.8 0.0001115 1.8 0.000111999 1.8 0.000112 0 0.000112499 0 0.0001125 0 0.000112999 0 0.000113 0 0.000113499 0 0.0001135 0 0.000113999 0 0.000114 1.8 0.000114499 1.8 0.0001145 1.8 0.000114999 1.8 0.000115 1.8 0.000115499 1.8 0.0001155 1.8 0.000115999 1.8 0.000116 0 0.000116499 0 0.0001165 0 0.000116999 0 0.000117 0 0.000117499 0 0.0001175 0 0.000117999 0 0.000118 1.8 0.000118499 1.8 0.0001185 1.8 0.000118999 1.8 0.000119 1.8 0.000119499 1.8 0.0001195 1.8 0.000119999 1.8 0.00012 0 0.000120499 0 0.0001205 0 0.000120999 0 0.000121 0 0.000121499 0 0.0001215 0 0.000121999 0 0.000122 1.8 0.000122499 1.8 0.0001225 1.8 0.000122999 1.8 0.000123 1.8 0.000123499 1.8 0.0001235 1.8 0.000123999 1.8 0.000124 0 0.000124499 0 0.0001245 0 0.000124999 0 0.000125 0 0.000125499 0 0.0001255 0 0.000125999 0 0.000126 1.8 0.000126499 1.8 0.0001265 1.8 0.000126999 1.8 0.000127 1.8 0.000127499 1.8 0.0001275 1.8 0.000128 1.8)
V4 B_R[3] GND PWL(0 0 4.99e-07 0 5e-07 0 9.99e-07 0 1e-06 0 1.499e-06 0 1.5e-06 0 1.999e-06 0 2e-06 0 2.499e-06 0 2.5e-06 0 2.999e-06 0 3e-06 0 3.499e-06 0 3.5e-06 0 3.999e-06 0 4e-06 1.8 4.499e-06 1.8 4.5e-06 1.8 4.999e-06 1.8 5e-06 1.8 5.499e-06 1.8 5.5e-06 1.8 5.999e-06 1.8 6e-06 1.8 6.499e-06 1.8 6.5e-06 1.8 6.999e-06 1.8 7e-06 1.8 7.499e-06 1.8 7.5e-06 1.8 7.999e-06 1.8 8e-06 0 8.499e-06 0 8.5e-06 0 8.999e-06 0 9e-06 0 9.499e-06 0 9.5e-06 0 9.999e-06 0 1e-05 0 1.0499e-05 0 1.05e-05 0 1.0999e-05 0 1.1e-05 0 1.1499e-05 0 1.15e-05 0 1.1999e-05 0 1.2e-05 1.8 1.2499e-05 1.8 1.25e-05 1.8 1.2999e-05 1.8 1.3e-05 1.8 1.3499e-05 1.8 1.35e-05 1.8 1.3999e-05 1.8 1.4e-05 1.8 1.4499e-05 1.8 1.45e-05 1.8 1.4999e-05 1.8 1.5e-05 1.8 1.5499e-05 1.8 1.55e-05 1.8 1.5999e-05 1.8 1.6e-05 0 1.6499e-05 0 1.65e-05 0 1.6999e-05 0 1.7e-05 0 1.7499e-05 0 1.75e-05 0 1.7999e-05 0 1.8e-05 0 1.8499e-05 0 1.85e-05 0 1.8999e-05 0 1.9e-05 0 1.9499e-05 0 1.95e-05 0 1.9999e-05 0 2e-05 1.8 2.0499e-05 1.8 2.05e-05 1.8 2.0999e-05 1.8 2.1e-05 1.8 2.1499e-05 1.8 2.15e-05 1.8 2.1999e-05 1.8 2.2e-05 1.8 2.2499e-05 1.8 2.25e-05 1.8 2.2999e-05 1.8 2.3e-05 1.8 2.3499e-05 1.8 2.35e-05 1.8 2.3999e-05 1.8 2.4e-05 0 2.4499e-05 0 2.45e-05 0 2.4999e-05 0 2.5e-05 0 2.5499e-05 0 2.55e-05 0 2.5999e-05 0 2.6e-05 0 2.6499e-05 0 2.65e-05 0 2.6999e-05 0 2.7e-05 0 2.7499e-05 0 2.75e-05 0 2.7999e-05 0 2.8e-05 1.8 2.8499e-05 1.8 2.85e-05 1.8 2.8999e-05 1.8 2.9e-05 1.8 2.9499e-05 1.8 2.95e-05 1.8 2.9999e-05 1.8 3e-05 1.8 3.0499e-05 1.8 3.05e-05 1.8 3.0999e-05 1.8 3.1e-05 1.8 3.1499e-05 1.8 3.15e-05 1.8 3.1999e-05 1.8 3.2e-05 0 3.2499e-05 0 3.25e-05 0 3.2999e-05 0 3.3e-05 0 3.3499e-05 0 3.35e-05 0 3.3999e-05 0 3.4e-05 0 3.4499e-05 0 3.45e-05 0 3.4999e-05 0 3.5e-05 0 3.5499e-05 0 3.55e-05 0 3.5999e-05 0 3.6e-05 1.8 3.6499e-05 1.8 3.65e-05 1.8 3.6999e-05 1.8 3.7e-05 1.8 3.7499e-05 1.8 3.75e-05 1.8 3.7999e-05 1.8 3.8e-05 1.8 3.8499e-05 1.8 3.85e-05 1.8 3.8999e-05 1.8 3.9e-05 1.8 3.9499e-05 1.8 3.95e-05 1.8 3.9999e-05 1.8 4e-05 0 4.0499e-05 0 4.05e-05 0 4.0999e-05 0 4.1e-05 0 4.1499e-05 0 4.15e-05 0 4.1999e-05 0 4.2e-05 0 4.2499e-05 0 4.25e-05 0 4.2999e-05 0 4.3e-05 0 4.3499e-05 0 4.35e-05 0 4.3999e-05 0 4.4e-05 1.8 4.4499e-05 1.8 4.45e-05 1.8 4.4999e-05 1.8 4.5e-05 1.8 4.5499e-05 1.8 4.55e-05 1.8 4.5999e-05 1.8 4.6e-05 1.8 4.6499e-05 1.8 4.65e-05 1.8 4.6999e-05 1.8 4.7e-05 1.8 4.7499e-05 1.8 4.75e-05 1.8 4.7999e-05 1.8 4.8e-05 0 4.8499e-05 0 4.85e-05 0 4.8999e-05 0 4.9e-05 0 4.9499e-05 0 4.95e-05 0 4.9999e-05 0 5e-05 0 5.0499e-05 0 5.05e-05 0 5.0999e-05 0 5.1e-05 0 5.1499e-05 0 5.15e-05 0 5.1999e-05 0 5.2e-05 1.8 5.2499e-05 1.8 5.25e-05 1.8 5.2999e-05 1.8 5.3e-05 1.8 5.3499e-05 1.8 5.35e-05 1.8 5.3999e-05 1.8 5.4e-05 1.8 5.4499e-05 1.8 5.45e-05 1.8 5.4999e-05 1.8 5.5e-05 1.8 5.5499e-05 1.8 5.55e-05 1.8 5.5999e-05 1.8 5.6e-05 0 5.6499e-05 0 5.65e-05 0 5.6999e-05 0 5.7e-05 0 5.7499e-05 0 5.75e-05 0 5.7999e-05 0 5.8e-05 0 5.8499e-05 0 5.85e-05 0 5.8999e-05 0 5.9e-05 0 5.9499e-05 0 5.95e-05 0 5.9999e-05 0 6e-05 1.8 6.0499e-05 1.8 6.05e-05 1.8 6.0999e-05 1.8 6.1e-05 1.8 6.1499e-05 1.8 6.15e-05 1.8 6.1999e-05 1.8 6.2e-05 1.8 6.2499e-05 1.8 6.25e-05 1.8 6.2999e-05 1.8 6.3e-05 1.8 6.3499e-05 1.8 6.35e-05 1.8 6.3999e-05 1.8 6.4e-05 0 6.4499e-05 0 6.45e-05 0 6.4999e-05 0 6.5e-05 0 6.5499e-05 0 6.55e-05 0 6.5999e-05 0 6.6e-05 0 6.6499e-05 0 6.65e-05 0 6.6999e-05 0 6.7e-05 0 6.7499e-05 0 6.75e-05 0 6.7999e-05 0 6.8e-05 1.8 6.8499e-05 1.8 6.85e-05 1.8 6.8999e-05 1.8 6.9e-05 1.8 6.9499e-05 1.8 6.95e-05 1.8 6.9999e-05 1.8 7e-05 1.8 7.0499e-05 1.8 7.05e-05 1.8 7.0999e-05 1.8 7.1e-05 1.8 7.1499e-05 1.8 7.15e-05 1.8 7.1999e-05 1.8 7.2e-05 0 7.2499e-05 0 7.25e-05 0 7.2999e-05 0 7.3e-05 0 7.3499e-05 0 7.35e-05 0 7.3999e-05 0 7.4e-05 0 7.4499e-05 0 7.45e-05 0 7.4999e-05 0 7.5e-05 0 7.5499e-05 0 7.55e-05 0 7.5999e-05 0 7.6e-05 1.8 7.6499e-05 1.8 7.65e-05 1.8 7.6999e-05 1.8 7.7e-05 1.8 7.7499e-05 1.8 7.75e-05 1.8 7.7999e-05 1.8 7.8e-05 1.8 7.8499e-05 1.8 7.85e-05 1.8 7.8999e-05 1.8 7.9e-05 1.8 7.9499e-05 1.8 7.95e-05 1.8 7.9999e-05 1.8 8e-05 0 8.0499e-05 0 8.05e-05 0 8.0999e-05 0 8.1e-05 0 8.1499e-05 0 8.15e-05 0 8.1999e-05 0 8.2e-05 0 8.2499e-05 0 8.25e-05 0 8.2999e-05 0 8.3e-05 0 8.3499e-05 0 8.35e-05 0 8.3999e-05 0 8.4e-05 1.8 8.4499e-05 1.8 8.45e-05 1.8 8.4999e-05 1.8 8.5e-05 1.8 8.5499e-05 1.8 8.55e-05 1.8 8.5999e-05 1.8 8.6e-05 1.8 8.6499e-05 1.8 8.65e-05 1.8 8.6999e-05 1.8 8.7e-05 1.8 8.7499e-05 1.8 8.75e-05 1.8 8.7999e-05 1.8 8.8e-05 0 8.8499e-05 0 8.85e-05 0 8.8999e-05 0 8.9e-05 0 8.9499e-05 0 8.95e-05 0 8.9999e-05 0 9e-05 0 9.0499e-05 0 9.05e-05 0 9.0999e-05 0 9.1e-05 0 9.1499e-05 0 9.15e-05 0 9.1999e-05 0 9.2e-05 1.8 9.2499e-05 1.8 9.25e-05 1.8 9.2999e-05 1.8 9.3e-05 1.8 9.3499e-05 1.8 9.35e-05 1.8 9.3999e-05 1.8 9.4e-05 1.8 9.4499e-05 1.8 9.45e-05 1.8 9.4999e-05 1.8 9.5e-05 1.8 9.5499e-05 1.8 9.55e-05 1.8 9.5999e-05 1.8 9.6e-05 0 9.6499e-05 0 9.65e-05 0 9.6999e-05 0 9.7e-05 0 9.7499e-05 0 9.75e-05 0 9.7999e-05 0 9.8e-05 0 9.8499e-05 0 9.85e-05 0 9.8999e-05 0 9.9e-05 0 9.9499e-05 0 9.95e-05 0 9.9999e-05 0 0.0001 1.8 0.000100499 1.8 0.0001005 1.8 0.000100999 1.8 0.000101 1.8 0.000101499 1.8 0.0001015 1.8 0.000101999 1.8 0.000102 1.8 0.000102499 1.8 0.0001025 1.8 0.000102999 1.8 0.000103 1.8 0.000103499 1.8 0.0001035 1.8 0.000103999 1.8 0.000104 0 0.000104499 0 0.0001045 0 0.000104999 0 0.000105 0 0.000105499 0 0.0001055 0 0.000105999 0 0.000106 0 0.000106499 0 0.0001065 0 0.000106999 0 0.000107 0 0.000107499 0 0.0001075 0 0.000107999 0 0.000108 1.8 0.000108499 1.8 0.0001085 1.8 0.000108999 1.8 0.000109 1.8 0.000109499 1.8 0.0001095 1.8 0.000109999 1.8 0.00011 1.8 0.000110499 1.8 0.0001105 1.8 0.000110999 1.8 0.000111 1.8 0.000111499 1.8 0.0001115 1.8 0.000111999 1.8 0.000112 0 0.000112499 0 0.0001125 0 0.000112999 0 0.000113 0 0.000113499 0 0.0001135 0 0.000113999 0 0.000114 0 0.000114499 0 0.0001145 0 0.000114999 0 0.000115 0 0.000115499 0 0.0001155 0 0.000115999 0 0.000116 1.8 0.000116499 1.8 0.0001165 1.8 0.000116999 1.8 0.000117 1.8 0.000117499 1.8 0.0001175 1.8 0.000117999 1.8 0.000118 1.8 0.000118499 1.8 0.0001185 1.8 0.000118999 1.8 0.000119 1.8 0.000119499 1.8 0.0001195 1.8 0.000119999 1.8 0.00012 0 0.000120499 0 0.0001205 0 0.000120999 0 0.000121 0 0.000121499 0 0.0001215 0 0.000121999 0 0.000122 0 0.000122499 0 0.0001225 0 0.000122999 0 0.000123 0 0.000123499 0 0.0001235 0 0.000123999 0 0.000124 1.8 0.000124499 1.8 0.0001245 1.8 0.000124999 1.8 0.000125 1.8 0.000125499 1.8 0.0001255 1.8 0.000125999 1.8 0.000126 1.8 0.000126499 1.8 0.0001265 1.8 0.000126999 1.8 0.000127 1.8 0.000127499 1.8 0.0001275 1.8 0.000128 1.8)
V5 B_R[4] GND PWL(0 0 4.99e-07 0 5e-07 0 9.99e-07 0 1e-06 0 1.499e-06 0 1.5e-06 0 1.999e-06 0 2e-06 0 2.499e-06 0 2.5e-06 0 2.999e-06 0 3e-06 0 3.499e-06 0 3.5e-06 0 3.999e-06 0 4e-06 0 4.499e-06 0 4.5e-06 0 4.999e-06 0 5e-06 0 5.499e-06 0 5.5e-06 0 5.999e-06 0 6e-06 0 6.499e-06 0 6.5e-06 0 6.999e-06 0 7e-06 0 7.499e-06 0 7.5e-06 0 7.999e-06 0 8e-06 1.8 8.499e-06 1.8 8.5e-06 1.8 8.999e-06 1.8 9e-06 1.8 9.499e-06 1.8 9.5e-06 1.8 9.999e-06 1.8 1e-05 1.8 1.0499e-05 1.8 1.05e-05 1.8 1.0999e-05 1.8 1.1e-05 1.8 1.1499e-05 1.8 1.15e-05 1.8 1.1999e-05 1.8 1.2e-05 1.8 1.2499e-05 1.8 1.25e-05 1.8 1.2999e-05 1.8 1.3e-05 1.8 1.3499e-05 1.8 1.35e-05 1.8 1.3999e-05 1.8 1.4e-05 1.8 1.4499e-05 1.8 1.45e-05 1.8 1.4999e-05 1.8 1.5e-05 1.8 1.5499e-05 1.8 1.55e-05 1.8 1.5999e-05 1.8 1.6e-05 0 1.6499e-05 0 1.65e-05 0 1.6999e-05 0 1.7e-05 0 1.7499e-05 0 1.75e-05 0 1.7999e-05 0 1.8e-05 0 1.8499e-05 0 1.85e-05 0 1.8999e-05 0 1.9e-05 0 1.9499e-05 0 1.95e-05 0 1.9999e-05 0 2e-05 0 2.0499e-05 0 2.05e-05 0 2.0999e-05 0 2.1e-05 0 2.1499e-05 0 2.15e-05 0 2.1999e-05 0 2.2e-05 0 2.2499e-05 0 2.25e-05 0 2.2999e-05 0 2.3e-05 0 2.3499e-05 0 2.35e-05 0 2.3999e-05 0 2.4e-05 1.8 2.4499e-05 1.8 2.45e-05 1.8 2.4999e-05 1.8 2.5e-05 1.8 2.5499e-05 1.8 2.55e-05 1.8 2.5999e-05 1.8 2.6e-05 1.8 2.6499e-05 1.8 2.65e-05 1.8 2.6999e-05 1.8 2.7e-05 1.8 2.7499e-05 1.8 2.75e-05 1.8 2.7999e-05 1.8 2.8e-05 1.8 2.8499e-05 1.8 2.85e-05 1.8 2.8999e-05 1.8 2.9e-05 1.8 2.9499e-05 1.8 2.95e-05 1.8 2.9999e-05 1.8 3e-05 1.8 3.0499e-05 1.8 3.05e-05 1.8 3.0999e-05 1.8 3.1e-05 1.8 3.1499e-05 1.8 3.15e-05 1.8 3.1999e-05 1.8 3.2e-05 0 3.2499e-05 0 3.25e-05 0 3.2999e-05 0 3.3e-05 0 3.3499e-05 0 3.35e-05 0 3.3999e-05 0 3.4e-05 0 3.4499e-05 0 3.45e-05 0 3.4999e-05 0 3.5e-05 0 3.5499e-05 0 3.55e-05 0 3.5999e-05 0 3.6e-05 0 3.6499e-05 0 3.65e-05 0 3.6999e-05 0 3.7e-05 0 3.7499e-05 0 3.75e-05 0 3.7999e-05 0 3.8e-05 0 3.8499e-05 0 3.85e-05 0 3.8999e-05 0 3.9e-05 0 3.9499e-05 0 3.95e-05 0 3.9999e-05 0 4e-05 1.8 4.0499e-05 1.8 4.05e-05 1.8 4.0999e-05 1.8 4.1e-05 1.8 4.1499e-05 1.8 4.15e-05 1.8 4.1999e-05 1.8 4.2e-05 1.8 4.2499e-05 1.8 4.25e-05 1.8 4.2999e-05 1.8 4.3e-05 1.8 4.3499e-05 1.8 4.35e-05 1.8 4.3999e-05 1.8 4.4e-05 1.8 4.4499e-05 1.8 4.45e-05 1.8 4.4999e-05 1.8 4.5e-05 1.8 4.5499e-05 1.8 4.55e-05 1.8 4.5999e-05 1.8 4.6e-05 1.8 4.6499e-05 1.8 4.65e-05 1.8 4.6999e-05 1.8 4.7e-05 1.8 4.7499e-05 1.8 4.75e-05 1.8 4.7999e-05 1.8 4.8e-05 0 4.8499e-05 0 4.85e-05 0 4.8999e-05 0 4.9e-05 0 4.9499e-05 0 4.95e-05 0 4.9999e-05 0 5e-05 0 5.0499e-05 0 5.05e-05 0 5.0999e-05 0 5.1e-05 0 5.1499e-05 0 5.15e-05 0 5.1999e-05 0 5.2e-05 0 5.2499e-05 0 5.25e-05 0 5.2999e-05 0 5.3e-05 0 5.3499e-05 0 5.35e-05 0 5.3999e-05 0 5.4e-05 0 5.4499e-05 0 5.45e-05 0 5.4999e-05 0 5.5e-05 0 5.5499e-05 0 5.55e-05 0 5.5999e-05 0 5.6e-05 1.8 5.6499e-05 1.8 5.65e-05 1.8 5.6999e-05 1.8 5.7e-05 1.8 5.7499e-05 1.8 5.75e-05 1.8 5.7999e-05 1.8 5.8e-05 1.8 5.8499e-05 1.8 5.85e-05 1.8 5.8999e-05 1.8 5.9e-05 1.8 5.9499e-05 1.8 5.95e-05 1.8 5.9999e-05 1.8 6e-05 1.8 6.0499e-05 1.8 6.05e-05 1.8 6.0999e-05 1.8 6.1e-05 1.8 6.1499e-05 1.8 6.15e-05 1.8 6.1999e-05 1.8 6.2e-05 1.8 6.2499e-05 1.8 6.25e-05 1.8 6.2999e-05 1.8 6.3e-05 1.8 6.3499e-05 1.8 6.35e-05 1.8 6.3999e-05 1.8 6.4e-05 0 6.4499e-05 0 6.45e-05 0 6.4999e-05 0 6.5e-05 0 6.5499e-05 0 6.55e-05 0 6.5999e-05 0 6.6e-05 0 6.6499e-05 0 6.65e-05 0 6.6999e-05 0 6.7e-05 0 6.7499e-05 0 6.75e-05 0 6.7999e-05 0 6.8e-05 0 6.8499e-05 0 6.85e-05 0 6.8999e-05 0 6.9e-05 0 6.9499e-05 0 6.95e-05 0 6.9999e-05 0 7e-05 0 7.0499e-05 0 7.05e-05 0 7.0999e-05 0 7.1e-05 0 7.1499e-05 0 7.15e-05 0 7.1999e-05 0 7.2e-05 1.8 7.2499e-05 1.8 7.25e-05 1.8 7.2999e-05 1.8 7.3e-05 1.8 7.3499e-05 1.8 7.35e-05 1.8 7.3999e-05 1.8 7.4e-05 1.8 7.4499e-05 1.8 7.45e-05 1.8 7.4999e-05 1.8 7.5e-05 1.8 7.5499e-05 1.8 7.55e-05 1.8 7.5999e-05 1.8 7.6e-05 1.8 7.6499e-05 1.8 7.65e-05 1.8 7.6999e-05 1.8 7.7e-05 1.8 7.7499e-05 1.8 7.75e-05 1.8 7.7999e-05 1.8 7.8e-05 1.8 7.8499e-05 1.8 7.85e-05 1.8 7.8999e-05 1.8 7.9e-05 1.8 7.9499e-05 1.8 7.95e-05 1.8 7.9999e-05 1.8 8e-05 0 8.0499e-05 0 8.05e-05 0 8.0999e-05 0 8.1e-05 0 8.1499e-05 0 8.15e-05 0 8.1999e-05 0 8.2e-05 0 8.2499e-05 0 8.25e-05 0 8.2999e-05 0 8.3e-05 0 8.3499e-05 0 8.35e-05 0 8.3999e-05 0 8.4e-05 0 8.4499e-05 0 8.45e-05 0 8.4999e-05 0 8.5e-05 0 8.5499e-05 0 8.55e-05 0 8.5999e-05 0 8.6e-05 0 8.6499e-05 0 8.65e-05 0 8.6999e-05 0 8.7e-05 0 8.7499e-05 0 8.75e-05 0 8.7999e-05 0 8.8e-05 1.8 8.8499e-05 1.8 8.85e-05 1.8 8.8999e-05 1.8 8.9e-05 1.8 8.9499e-05 1.8 8.95e-05 1.8 8.9999e-05 1.8 9e-05 1.8 9.0499e-05 1.8 9.05e-05 1.8 9.0999e-05 1.8 9.1e-05 1.8 9.1499e-05 1.8 9.15e-05 1.8 9.1999e-05 1.8 9.2e-05 1.8 9.2499e-05 1.8 9.25e-05 1.8 9.2999e-05 1.8 9.3e-05 1.8 9.3499e-05 1.8 9.35e-05 1.8 9.3999e-05 1.8 9.4e-05 1.8 9.4499e-05 1.8 9.45e-05 1.8 9.4999e-05 1.8 9.5e-05 1.8 9.5499e-05 1.8 9.55e-05 1.8 9.5999e-05 1.8 9.6e-05 0 9.6499e-05 0 9.65e-05 0 9.6999e-05 0 9.7e-05 0 9.7499e-05 0 9.75e-05 0 9.7999e-05 0 9.8e-05 0 9.8499e-05 0 9.85e-05 0 9.8999e-05 0 9.9e-05 0 9.9499e-05 0 9.95e-05 0 9.9999e-05 0 0.0001 0 0.000100499 0 0.0001005 0 0.000100999 0 0.000101 0 0.000101499 0 0.0001015 0 0.000101999 0 0.000102 0 0.000102499 0 0.0001025 0 0.000102999 0 0.000103 0 0.000103499 0 0.0001035 0 0.000103999 0 0.000104 1.8 0.000104499 1.8 0.0001045 1.8 0.000104999 1.8 0.000105 1.8 0.000105499 1.8 0.0001055 1.8 0.000105999 1.8 0.000106 1.8 0.000106499 1.8 0.0001065 1.8 0.000106999 1.8 0.000107 1.8 0.000107499 1.8 0.0001075 1.8 0.000107999 1.8 0.000108 1.8 0.000108499 1.8 0.0001085 1.8 0.000108999 1.8 0.000109 1.8 0.000109499 1.8 0.0001095 1.8 0.000109999 1.8 0.00011 1.8 0.000110499 1.8 0.0001105 1.8 0.000110999 1.8 0.000111 1.8 0.000111499 1.8 0.0001115 1.8 0.000111999 1.8 0.000112 0 0.000112499 0 0.0001125 0 0.000112999 0 0.000113 0 0.000113499 0 0.0001135 0 0.000113999 0 0.000114 0 0.000114499 0 0.0001145 0 0.000114999 0 0.000115 0 0.000115499 0 0.0001155 0 0.000115999 0 0.000116 0 0.000116499 0 0.0001165 0 0.000116999 0 0.000117 0 0.000117499 0 0.0001175 0 0.000117999 0 0.000118 0 0.000118499 0 0.0001185 0 0.000118999 0 0.000119 0 0.000119499 0 0.0001195 0 0.000119999 0 0.00012 1.8 0.000120499 1.8 0.0001205 1.8 0.000120999 1.8 0.000121 1.8 0.000121499 1.8 0.0001215 1.8 0.000121999 1.8 0.000122 1.8 0.000122499 1.8 0.0001225 1.8 0.000122999 1.8 0.000123 1.8 0.000123499 1.8 0.0001235 1.8 0.000123999 1.8 0.000124 1.8 0.000124499 1.8 0.0001245 1.8 0.000124999 1.8 0.000125 1.8 0.000125499 1.8 0.0001255 1.8 0.000125999 1.8 0.000126 1.8 0.000126499 1.8 0.0001265 1.8 0.000126999 1.8 0.000127 1.8 0.000127499 1.8 0.0001275 1.8 0.000128 1.8)
V6 B_R[5] GND PWL(0 0 4.99e-07 0 5e-07 0 9.99e-07 0 1e-06 0 1.499e-06 0 1.5e-06 0 1.999e-06 0 2e-06 0 2.499e-06 0 2.5e-06 0 2.999e-06 0 3e-06 0 3.499e-06 0 3.5e-06 0 3.999e-06 0 4e-06 0 4.499e-06 0 4.5e-06 0 4.999e-06 0 5e-06 0 5.499e-06 0 5.5e-06 0 5.999e-06 0 6e-06 0 6.499e-06 0 6.5e-06 0 6.999e-06 0 7e-06 0 7.499e-06 0 7.5e-06 0 7.999e-06 0 8e-06 0 8.499e-06 0 8.5e-06 0 8.999e-06 0 9e-06 0 9.499e-06 0 9.5e-06 0 9.999e-06 0 1e-05 0 1.0499e-05 0 1.05e-05 0 1.0999e-05 0 1.1e-05 0 1.1499e-05 0 1.15e-05 0 1.1999e-05 0 1.2e-05 0 1.2499e-05 0 1.25e-05 0 1.2999e-05 0 1.3e-05 0 1.3499e-05 0 1.35e-05 0 1.3999e-05 0 1.4e-05 0 1.4499e-05 0 1.45e-05 0 1.4999e-05 0 1.5e-05 0 1.5499e-05 0 1.55e-05 0 1.5999e-05 0 1.6e-05 1.8 1.6499e-05 1.8 1.65e-05 1.8 1.6999e-05 1.8 1.7e-05 1.8 1.7499e-05 1.8 1.75e-05 1.8 1.7999e-05 1.8 1.8e-05 1.8 1.8499e-05 1.8 1.85e-05 1.8 1.8999e-05 1.8 1.9e-05 1.8 1.9499e-05 1.8 1.95e-05 1.8 1.9999e-05 1.8 2e-05 1.8 2.0499e-05 1.8 2.05e-05 1.8 2.0999e-05 1.8 2.1e-05 1.8 2.1499e-05 1.8 2.15e-05 1.8 2.1999e-05 1.8 2.2e-05 1.8 2.2499e-05 1.8 2.25e-05 1.8 2.2999e-05 1.8 2.3e-05 1.8 2.3499e-05 1.8 2.35e-05 1.8 2.3999e-05 1.8 2.4e-05 1.8 2.4499e-05 1.8 2.45e-05 1.8 2.4999e-05 1.8 2.5e-05 1.8 2.5499e-05 1.8 2.55e-05 1.8 2.5999e-05 1.8 2.6e-05 1.8 2.6499e-05 1.8 2.65e-05 1.8 2.6999e-05 1.8 2.7e-05 1.8 2.7499e-05 1.8 2.75e-05 1.8 2.7999e-05 1.8 2.8e-05 1.8 2.8499e-05 1.8 2.85e-05 1.8 2.8999e-05 1.8 2.9e-05 1.8 2.9499e-05 1.8 2.95e-05 1.8 2.9999e-05 1.8 3e-05 1.8 3.0499e-05 1.8 3.05e-05 1.8 3.0999e-05 1.8 3.1e-05 1.8 3.1499e-05 1.8 3.15e-05 1.8 3.1999e-05 1.8 3.2e-05 0 3.2499e-05 0 3.25e-05 0 3.2999e-05 0 3.3e-05 0 3.3499e-05 0 3.35e-05 0 3.3999e-05 0 3.4e-05 0 3.4499e-05 0 3.45e-05 0 3.4999e-05 0 3.5e-05 0 3.5499e-05 0 3.55e-05 0 3.5999e-05 0 3.6e-05 0 3.6499e-05 0 3.65e-05 0 3.6999e-05 0 3.7e-05 0 3.7499e-05 0 3.75e-05 0 3.7999e-05 0 3.8e-05 0 3.8499e-05 0 3.85e-05 0 3.8999e-05 0 3.9e-05 0 3.9499e-05 0 3.95e-05 0 3.9999e-05 0 4e-05 0 4.0499e-05 0 4.05e-05 0 4.0999e-05 0 4.1e-05 0 4.1499e-05 0 4.15e-05 0 4.1999e-05 0 4.2e-05 0 4.2499e-05 0 4.25e-05 0 4.2999e-05 0 4.3e-05 0 4.3499e-05 0 4.35e-05 0 4.3999e-05 0 4.4e-05 0 4.4499e-05 0 4.45e-05 0 4.4999e-05 0 4.5e-05 0 4.5499e-05 0 4.55e-05 0 4.5999e-05 0 4.6e-05 0 4.6499e-05 0 4.65e-05 0 4.6999e-05 0 4.7e-05 0 4.7499e-05 0 4.75e-05 0 4.7999e-05 0 4.8e-05 1.8 4.8499e-05 1.8 4.85e-05 1.8 4.8999e-05 1.8 4.9e-05 1.8 4.9499e-05 1.8 4.95e-05 1.8 4.9999e-05 1.8 5e-05 1.8 5.0499e-05 1.8 5.05e-05 1.8 5.0999e-05 1.8 5.1e-05 1.8 5.1499e-05 1.8 5.15e-05 1.8 5.1999e-05 1.8 5.2e-05 1.8 5.2499e-05 1.8 5.25e-05 1.8 5.2999e-05 1.8 5.3e-05 1.8 5.3499e-05 1.8 5.35e-05 1.8 5.3999e-05 1.8 5.4e-05 1.8 5.4499e-05 1.8 5.45e-05 1.8 5.4999e-05 1.8 5.5e-05 1.8 5.5499e-05 1.8 5.55e-05 1.8 5.5999e-05 1.8 5.6e-05 1.8 5.6499e-05 1.8 5.65e-05 1.8 5.6999e-05 1.8 5.7e-05 1.8 5.7499e-05 1.8 5.75e-05 1.8 5.7999e-05 1.8 5.8e-05 1.8 5.8499e-05 1.8 5.85e-05 1.8 5.8999e-05 1.8 5.9e-05 1.8 5.9499e-05 1.8 5.95e-05 1.8 5.9999e-05 1.8 6e-05 1.8 6.0499e-05 1.8 6.05e-05 1.8 6.0999e-05 1.8 6.1e-05 1.8 6.1499e-05 1.8 6.15e-05 1.8 6.1999e-05 1.8 6.2e-05 1.8 6.2499e-05 1.8 6.25e-05 1.8 6.2999e-05 1.8 6.3e-05 1.8 6.3499e-05 1.8 6.35e-05 1.8 6.3999e-05 1.8 6.4e-05 0 6.4499e-05 0 6.45e-05 0 6.4999e-05 0 6.5e-05 0 6.5499e-05 0 6.55e-05 0 6.5999e-05 0 6.6e-05 0 6.6499e-05 0 6.65e-05 0 6.6999e-05 0 6.7e-05 0 6.7499e-05 0 6.75e-05 0 6.7999e-05 0 6.8e-05 0 6.8499e-05 0 6.85e-05 0 6.8999e-05 0 6.9e-05 0 6.9499e-05 0 6.95e-05 0 6.9999e-05 0 7e-05 0 7.0499e-05 0 7.05e-05 0 7.0999e-05 0 7.1e-05 0 7.1499e-05 0 7.15e-05 0 7.1999e-05 0 7.2e-05 0 7.2499e-05 0 7.25e-05 0 7.2999e-05 0 7.3e-05 0 7.3499e-05 0 7.35e-05 0 7.3999e-05 0 7.4e-05 0 7.4499e-05 0 7.45e-05 0 7.4999e-05 0 7.5e-05 0 7.5499e-05 0 7.55e-05 0 7.5999e-05 0 7.6e-05 0 7.6499e-05 0 7.65e-05 0 7.6999e-05 0 7.7e-05 0 7.7499e-05 0 7.75e-05 0 7.7999e-05 0 7.8e-05 0 7.8499e-05 0 7.85e-05 0 7.8999e-05 0 7.9e-05 0 7.9499e-05 0 7.95e-05 0 7.9999e-05 0 8e-05 1.8 8.0499e-05 1.8 8.05e-05 1.8 8.0999e-05 1.8 8.1e-05 1.8 8.1499e-05 1.8 8.15e-05 1.8 8.1999e-05 1.8 8.2e-05 1.8 8.2499e-05 1.8 8.25e-05 1.8 8.2999e-05 1.8 8.3e-05 1.8 8.3499e-05 1.8 8.35e-05 1.8 8.3999e-05 1.8 8.4e-05 1.8 8.4499e-05 1.8 8.45e-05 1.8 8.4999e-05 1.8 8.5e-05 1.8 8.5499e-05 1.8 8.55e-05 1.8 8.5999e-05 1.8 8.6e-05 1.8 8.6499e-05 1.8 8.65e-05 1.8 8.6999e-05 1.8 8.7e-05 1.8 8.7499e-05 1.8 8.75e-05 1.8 8.7999e-05 1.8 8.8e-05 1.8 8.8499e-05 1.8 8.85e-05 1.8 8.8999e-05 1.8 8.9e-05 1.8 8.9499e-05 1.8 8.95e-05 1.8 8.9999e-05 1.8 9e-05 1.8 9.0499e-05 1.8 9.05e-05 1.8 9.0999e-05 1.8 9.1e-05 1.8 9.1499e-05 1.8 9.15e-05 1.8 9.1999e-05 1.8 9.2e-05 1.8 9.2499e-05 1.8 9.25e-05 1.8 9.2999e-05 1.8 9.3e-05 1.8 9.3499e-05 1.8 9.35e-05 1.8 9.3999e-05 1.8 9.4e-05 1.8 9.4499e-05 1.8 9.45e-05 1.8 9.4999e-05 1.8 9.5e-05 1.8 9.5499e-05 1.8 9.55e-05 1.8 9.5999e-05 1.8 9.6e-05 0 9.6499e-05 0 9.65e-05 0 9.6999e-05 0 9.7e-05 0 9.7499e-05 0 9.75e-05 0 9.7999e-05 0 9.8e-05 0 9.8499e-05 0 9.85e-05 0 9.8999e-05 0 9.9e-05 0 9.9499e-05 0 9.95e-05 0 9.9999e-05 0 0.0001 0 0.000100499 0 0.0001005 0 0.000100999 0 0.000101 0 0.000101499 0 0.0001015 0 0.000101999 0 0.000102 0 0.000102499 0 0.0001025 0 0.000102999 0 0.000103 0 0.000103499 0 0.0001035 0 0.000103999 0 0.000104 0 0.000104499 0 0.0001045 0 0.000104999 0 0.000105 0 0.000105499 0 0.0001055 0 0.000105999 0 0.000106 0 0.000106499 0 0.0001065 0 0.000106999 0 0.000107 0 0.000107499 0 0.0001075 0 0.000107999 0 0.000108 0 0.000108499 0 0.0001085 0 0.000108999 0 0.000109 0 0.000109499 0 0.0001095 0 0.000109999 0 0.00011 0 0.000110499 0 0.0001105 0 0.000110999 0 0.000111 0 0.000111499 0 0.0001115 0 0.000111999 0 0.000112 1.8 0.000112499 1.8 0.0001125 1.8 0.000112999 1.8 0.000113 1.8 0.000113499 1.8 0.0001135 1.8 0.000113999 1.8 0.000114 1.8 0.000114499 1.8 0.0001145 1.8 0.000114999 1.8 0.000115 1.8 0.000115499 1.8 0.0001155 1.8 0.000115999 1.8 0.000116 1.8 0.000116499 1.8 0.0001165 1.8 0.000116999 1.8 0.000117 1.8 0.000117499 1.8 0.0001175 1.8 0.000117999 1.8 0.000118 1.8 0.000118499 1.8 0.0001185 1.8 0.000118999 1.8 0.000119 1.8 0.000119499 1.8 0.0001195 1.8 0.000119999 1.8 0.00012 1.8 0.000120499 1.8 0.0001205 1.8 0.000120999 1.8 0.000121 1.8 0.000121499 1.8 0.0001215 1.8 0.000121999 1.8 0.000122 1.8 0.000122499 1.8 0.0001225 1.8 0.000122999 1.8 0.000123 1.8 0.000123499 1.8 0.0001235 1.8 0.000123999 1.8 0.000124 1.8 0.000124499 1.8 0.0001245 1.8 0.000124999 1.8 0.000125 1.8 0.000125499 1.8 0.0001255 1.8 0.000125999 1.8 0.000126 1.8 0.000126499 1.8 0.0001265 1.8 0.000126999 1.8 0.000127 1.8 0.000127499 1.8 0.0001275 1.8 0.000128 1.8)
V7 B_R[6] GND PWL(0 0 4.99e-07 0 5e-07 0 9.99e-07 0 1e-06 0 1.499e-06 0 1.5e-06 0 1.999e-06 0 2e-06 0 2.499e-06 0 2.5e-06 0 2.999e-06 0 3e-06 0 3.499e-06 0 3.5e-06 0 3.999e-06 0 4e-06 0 4.499e-06 0 4.5e-06 0 4.999e-06 0 5e-06 0 5.499e-06 0 5.5e-06 0 5.999e-06 0 6e-06 0 6.499e-06 0 6.5e-06 0 6.999e-06 0 7e-06 0 7.499e-06 0 7.5e-06 0 7.999e-06 0 8e-06 0 8.499e-06 0 8.5e-06 0 8.999e-06 0 9e-06 0 9.499e-06 0 9.5e-06 0 9.999e-06 0 1e-05 0 1.0499e-05 0 1.05e-05 0 1.0999e-05 0 1.1e-05 0 1.1499e-05 0 1.15e-05 0 1.1999e-05 0 1.2e-05 0 1.2499e-05 0 1.25e-05 0 1.2999e-05 0 1.3e-05 0 1.3499e-05 0 1.35e-05 0 1.3999e-05 0 1.4e-05 0 1.4499e-05 0 1.45e-05 0 1.4999e-05 0 1.5e-05 0 1.5499e-05 0 1.55e-05 0 1.5999e-05 0 1.6e-05 0 1.6499e-05 0 1.65e-05 0 1.6999e-05 0 1.7e-05 0 1.7499e-05 0 1.75e-05 0 1.7999e-05 0 1.8e-05 0 1.8499e-05 0 1.85e-05 0 1.8999e-05 0 1.9e-05 0 1.9499e-05 0 1.95e-05 0 1.9999e-05 0 2e-05 0 2.0499e-05 0 2.05e-05 0 2.0999e-05 0 2.1e-05 0 2.1499e-05 0 2.15e-05 0 2.1999e-05 0 2.2e-05 0 2.2499e-05 0 2.25e-05 0 2.2999e-05 0 2.3e-05 0 2.3499e-05 0 2.35e-05 0 2.3999e-05 0 2.4e-05 0 2.4499e-05 0 2.45e-05 0 2.4999e-05 0 2.5e-05 0 2.5499e-05 0 2.55e-05 0 2.5999e-05 0 2.6e-05 0 2.6499e-05 0 2.65e-05 0 2.6999e-05 0 2.7e-05 0 2.7499e-05 0 2.75e-05 0 2.7999e-05 0 2.8e-05 0 2.8499e-05 0 2.85e-05 0 2.8999e-05 0 2.9e-05 0 2.9499e-05 0 2.95e-05 0 2.9999e-05 0 3e-05 0 3.0499e-05 0 3.05e-05 0 3.0999e-05 0 3.1e-05 0 3.1499e-05 0 3.15e-05 0 3.1999e-05 0 3.2e-05 1.8 3.2499e-05 1.8 3.25e-05 1.8 3.2999e-05 1.8 3.3e-05 1.8 3.3499e-05 1.8 3.35e-05 1.8 3.3999e-05 1.8 3.4e-05 1.8 3.4499e-05 1.8 3.45e-05 1.8 3.4999e-05 1.8 3.5e-05 1.8 3.5499e-05 1.8 3.55e-05 1.8 3.5999e-05 1.8 3.6e-05 1.8 3.6499e-05 1.8 3.65e-05 1.8 3.6999e-05 1.8 3.7e-05 1.8 3.7499e-05 1.8 3.75e-05 1.8 3.7999e-05 1.8 3.8e-05 1.8 3.8499e-05 1.8 3.85e-05 1.8 3.8999e-05 1.8 3.9e-05 1.8 3.9499e-05 1.8 3.95e-05 1.8 3.9999e-05 1.8 4e-05 1.8 4.0499e-05 1.8 4.05e-05 1.8 4.0999e-05 1.8 4.1e-05 1.8 4.1499e-05 1.8 4.15e-05 1.8 4.1999e-05 1.8 4.2e-05 1.8 4.2499e-05 1.8 4.25e-05 1.8 4.2999e-05 1.8 4.3e-05 1.8 4.3499e-05 1.8 4.35e-05 1.8 4.3999e-05 1.8 4.4e-05 1.8 4.4499e-05 1.8 4.45e-05 1.8 4.4999e-05 1.8 4.5e-05 1.8 4.5499e-05 1.8 4.55e-05 1.8 4.5999e-05 1.8 4.6e-05 1.8 4.6499e-05 1.8 4.65e-05 1.8 4.6999e-05 1.8 4.7e-05 1.8 4.7499e-05 1.8 4.75e-05 1.8 4.7999e-05 1.8 4.8e-05 1.8 4.8499e-05 1.8 4.85e-05 1.8 4.8999e-05 1.8 4.9e-05 1.8 4.9499e-05 1.8 4.95e-05 1.8 4.9999e-05 1.8 5e-05 1.8 5.0499e-05 1.8 5.05e-05 1.8 5.0999e-05 1.8 5.1e-05 1.8 5.1499e-05 1.8 5.15e-05 1.8 5.1999e-05 1.8 5.2e-05 1.8 5.2499e-05 1.8 5.25e-05 1.8 5.2999e-05 1.8 5.3e-05 1.8 5.3499e-05 1.8 5.35e-05 1.8 5.3999e-05 1.8 5.4e-05 1.8 5.4499e-05 1.8 5.45e-05 1.8 5.4999e-05 1.8 5.5e-05 1.8 5.5499e-05 1.8 5.55e-05 1.8 5.5999e-05 1.8 5.6e-05 1.8 5.6499e-05 1.8 5.65e-05 1.8 5.6999e-05 1.8 5.7e-05 1.8 5.7499e-05 1.8 5.75e-05 1.8 5.7999e-05 1.8 5.8e-05 1.8 5.8499e-05 1.8 5.85e-05 1.8 5.8999e-05 1.8 5.9e-05 1.8 5.9499e-05 1.8 5.95e-05 1.8 5.9999e-05 1.8 6e-05 1.8 6.0499e-05 1.8 6.05e-05 1.8 6.0999e-05 1.8 6.1e-05 1.8 6.1499e-05 1.8 6.15e-05 1.8 6.1999e-05 1.8 6.2e-05 1.8 6.2499e-05 1.8 6.25e-05 1.8 6.2999e-05 1.8 6.3e-05 1.8 6.3499e-05 1.8 6.35e-05 1.8 6.3999e-05 1.8 6.4e-05 0 6.4499e-05 0 6.45e-05 0 6.4999e-05 0 6.5e-05 0 6.5499e-05 0 6.55e-05 0 6.5999e-05 0 6.6e-05 0 6.6499e-05 0 6.65e-05 0 6.6999e-05 0 6.7e-05 0 6.7499e-05 0 6.75e-05 0 6.7999e-05 0 6.8e-05 0 6.8499e-05 0 6.85e-05 0 6.8999e-05 0 6.9e-05 0 6.9499e-05 0 6.95e-05 0 6.9999e-05 0 7e-05 0 7.0499e-05 0 7.05e-05 0 7.0999e-05 0 7.1e-05 0 7.1499e-05 0 7.15e-05 0 7.1999e-05 0 7.2e-05 0 7.2499e-05 0 7.25e-05 0 7.2999e-05 0 7.3e-05 0 7.3499e-05 0 7.35e-05 0 7.3999e-05 0 7.4e-05 0 7.4499e-05 0 7.45e-05 0 7.4999e-05 0 7.5e-05 0 7.5499e-05 0 7.55e-05 0 7.5999e-05 0 7.6e-05 0 7.6499e-05 0 7.65e-05 0 7.6999e-05 0 7.7e-05 0 7.7499e-05 0 7.75e-05 0 7.7999e-05 0 7.8e-05 0 7.8499e-05 0 7.85e-05 0 7.8999e-05 0 7.9e-05 0 7.9499e-05 0 7.95e-05 0 7.9999e-05 0 8e-05 0 8.0499e-05 0 8.05e-05 0 8.0999e-05 0 8.1e-05 0 8.1499e-05 0 8.15e-05 0 8.1999e-05 0 8.2e-05 0 8.2499e-05 0 8.25e-05 0 8.2999e-05 0 8.3e-05 0 8.3499e-05 0 8.35e-05 0 8.3999e-05 0 8.4e-05 0 8.4499e-05 0 8.45e-05 0 8.4999e-05 0 8.5e-05 0 8.5499e-05 0 8.55e-05 0 8.5999e-05 0 8.6e-05 0 8.6499e-05 0 8.65e-05 0 8.6999e-05 0 8.7e-05 0 8.7499e-05 0 8.75e-05 0 8.7999e-05 0 8.8e-05 0 8.8499e-05 0 8.85e-05 0 8.8999e-05 0 8.9e-05 0 8.9499e-05 0 8.95e-05 0 8.9999e-05 0 9e-05 0 9.0499e-05 0 9.05e-05 0 9.0999e-05 0 9.1e-05 0 9.1499e-05 0 9.15e-05 0 9.1999e-05 0 9.2e-05 0 9.2499e-05 0 9.25e-05 0 9.2999e-05 0 9.3e-05 0 9.3499e-05 0 9.35e-05 0 9.3999e-05 0 9.4e-05 0 9.4499e-05 0 9.45e-05 0 9.4999e-05 0 9.5e-05 0 9.5499e-05 0 9.55e-05 0 9.5999e-05 0 9.6e-05 1.8 9.6499e-05 1.8 9.65e-05 1.8 9.6999e-05 1.8 9.7e-05 1.8 9.7499e-05 1.8 9.75e-05 1.8 9.7999e-05 1.8 9.8e-05 1.8 9.8499e-05 1.8 9.85e-05 1.8 9.8999e-05 1.8 9.9e-05 1.8 9.9499e-05 1.8 9.95e-05 1.8 9.9999e-05 1.8 0.0001 1.8 0.000100499 1.8 0.0001005 1.8 0.000100999 1.8 0.000101 1.8 0.000101499 1.8 0.0001015 1.8 0.000101999 1.8 0.000102 1.8 0.000102499 1.8 0.0001025 1.8 0.000102999 1.8 0.000103 1.8 0.000103499 1.8 0.0001035 1.8 0.000103999 1.8 0.000104 1.8 0.000104499 1.8 0.0001045 1.8 0.000104999 1.8 0.000105 1.8 0.000105499 1.8 0.0001055 1.8 0.000105999 1.8 0.000106 1.8 0.000106499 1.8 0.0001065 1.8 0.000106999 1.8 0.000107 1.8 0.000107499 1.8 0.0001075 1.8 0.000107999 1.8 0.000108 1.8 0.000108499 1.8 0.0001085 1.8 0.000108999 1.8 0.000109 1.8 0.000109499 1.8 0.0001095 1.8 0.000109999 1.8 0.00011 1.8 0.000110499 1.8 0.0001105 1.8 0.000110999 1.8 0.000111 1.8 0.000111499 1.8 0.0001115 1.8 0.000111999 1.8 0.000112 1.8 0.000112499 1.8 0.0001125 1.8 0.000112999 1.8 0.000113 1.8 0.000113499 1.8 0.0001135 1.8 0.000113999 1.8 0.000114 1.8 0.000114499 1.8 0.0001145 1.8 0.000114999 1.8 0.000115 1.8 0.000115499 1.8 0.0001155 1.8 0.000115999 1.8 0.000116 1.8 0.000116499 1.8 0.0001165 1.8 0.000116999 1.8 0.000117 1.8 0.000117499 1.8 0.0001175 1.8 0.000117999 1.8 0.000118 1.8 0.000118499 1.8 0.0001185 1.8 0.000118999 1.8 0.000119 1.8 0.000119499 1.8 0.0001195 1.8 0.000119999 1.8 0.00012 1.8 0.000120499 1.8 0.0001205 1.8 0.000120999 1.8 0.000121 1.8 0.000121499 1.8 0.0001215 1.8 0.000121999 1.8 0.000122 1.8 0.000122499 1.8 0.0001225 1.8 0.000122999 1.8 0.000123 1.8 0.000123499 1.8 0.0001235 1.8 0.000123999 1.8 0.000124 1.8 0.000124499 1.8 0.0001245 1.8 0.000124999 1.8 0.000125 1.8 0.000125499 1.8 0.0001255 1.8 0.000125999 1.8 0.000126 1.8 0.000126499 1.8 0.0001265 1.8 0.000126999 1.8 0.000127 1.8 0.000127499 1.8 0.0001275 1.8 0.000128 1.8)
V8 B_R[7] GND PWL(0 0 4.99e-07 0 5e-07 0 9.99e-07 0 1e-06 0 1.499e-06 0 1.5e-06 0 1.999e-06 0 2e-06 0 2.499e-06 0 2.5e-06 0 2.999e-06 0 3e-06 0 3.499e-06 0 3.5e-06 0 3.999e-06 0 4e-06 0 4.499e-06 0 4.5e-06 0 4.999e-06 0 5e-06 0 5.499e-06 0 5.5e-06 0 5.999e-06 0 6e-06 0 6.499e-06 0 6.5e-06 0 6.999e-06 0 7e-06 0 7.499e-06 0 7.5e-06 0 7.999e-06 0 8e-06 0 8.499e-06 0 8.5e-06 0 8.999e-06 0 9e-06 0 9.499e-06 0 9.5e-06 0 9.999e-06 0 1e-05 0 1.0499e-05 0 1.05e-05 0 1.0999e-05 0 1.1e-05 0 1.1499e-05 0 1.15e-05 0 1.1999e-05 0 1.2e-05 0 1.2499e-05 0 1.25e-05 0 1.2999e-05 0 1.3e-05 0 1.3499e-05 0 1.35e-05 0 1.3999e-05 0 1.4e-05 0 1.4499e-05 0 1.45e-05 0 1.4999e-05 0 1.5e-05 0 1.5499e-05 0 1.55e-05 0 1.5999e-05 0 1.6e-05 0 1.6499e-05 0 1.65e-05 0 1.6999e-05 0 1.7e-05 0 1.7499e-05 0 1.75e-05 0 1.7999e-05 0 1.8e-05 0 1.8499e-05 0 1.85e-05 0 1.8999e-05 0 1.9e-05 0 1.9499e-05 0 1.95e-05 0 1.9999e-05 0 2e-05 0 2.0499e-05 0 2.05e-05 0 2.0999e-05 0 2.1e-05 0 2.1499e-05 0 2.15e-05 0 2.1999e-05 0 2.2e-05 0 2.2499e-05 0 2.25e-05 0 2.2999e-05 0 2.3e-05 0 2.3499e-05 0 2.35e-05 0 2.3999e-05 0 2.4e-05 0 2.4499e-05 0 2.45e-05 0 2.4999e-05 0 2.5e-05 0 2.5499e-05 0 2.55e-05 0 2.5999e-05 0 2.6e-05 0 2.6499e-05 0 2.65e-05 0 2.6999e-05 0 2.7e-05 0 2.7499e-05 0 2.75e-05 0 2.7999e-05 0 2.8e-05 0 2.8499e-05 0 2.85e-05 0 2.8999e-05 0 2.9e-05 0 2.9499e-05 0 2.95e-05 0 2.9999e-05 0 3e-05 0 3.0499e-05 0 3.05e-05 0 3.0999e-05 0 3.1e-05 0 3.1499e-05 0 3.15e-05 0 3.1999e-05 0 3.2e-05 0 3.2499e-05 0 3.25e-05 0 3.2999e-05 0 3.3e-05 0 3.3499e-05 0 3.35e-05 0 3.3999e-05 0 3.4e-05 0 3.4499e-05 0 3.45e-05 0 3.4999e-05 0 3.5e-05 0 3.5499e-05 0 3.55e-05 0 3.5999e-05 0 3.6e-05 0 3.6499e-05 0 3.65e-05 0 3.6999e-05 0 3.7e-05 0 3.7499e-05 0 3.75e-05 0 3.7999e-05 0 3.8e-05 0 3.8499e-05 0 3.85e-05 0 3.8999e-05 0 3.9e-05 0 3.9499e-05 0 3.95e-05 0 3.9999e-05 0 4e-05 0 4.0499e-05 0 4.05e-05 0 4.0999e-05 0 4.1e-05 0 4.1499e-05 0 4.15e-05 0 4.1999e-05 0 4.2e-05 0 4.2499e-05 0 4.25e-05 0 4.2999e-05 0 4.3e-05 0 4.3499e-05 0 4.35e-05 0 4.3999e-05 0 4.4e-05 0 4.4499e-05 0 4.45e-05 0 4.4999e-05 0 4.5e-05 0 4.5499e-05 0 4.55e-05 0 4.5999e-05 0 4.6e-05 0 4.6499e-05 0 4.65e-05 0 4.6999e-05 0 4.7e-05 0 4.7499e-05 0 4.75e-05 0 4.7999e-05 0 4.8e-05 0 4.8499e-05 0 4.85e-05 0 4.8999e-05 0 4.9e-05 0 4.9499e-05 0 4.95e-05 0 4.9999e-05 0 5e-05 0 5.0499e-05 0 5.05e-05 0 5.0999e-05 0 5.1e-05 0 5.1499e-05 0 5.15e-05 0 5.1999e-05 0 5.2e-05 0 5.2499e-05 0 5.25e-05 0 5.2999e-05 0 5.3e-05 0 5.3499e-05 0 5.35e-05 0 5.3999e-05 0 5.4e-05 0 5.4499e-05 0 5.45e-05 0 5.4999e-05 0 5.5e-05 0 5.5499e-05 0 5.55e-05 0 5.5999e-05 0 5.6e-05 0 5.6499e-05 0 5.65e-05 0 5.6999e-05 0 5.7e-05 0 5.7499e-05 0 5.75e-05 0 5.7999e-05 0 5.8e-05 0 5.8499e-05 0 5.85e-05 0 5.8999e-05 0 5.9e-05 0 5.9499e-05 0 5.95e-05 0 5.9999e-05 0 6e-05 0 6.0499e-05 0 6.05e-05 0 6.0999e-05 0 6.1e-05 0 6.1499e-05 0 6.15e-05 0 6.1999e-05 0 6.2e-05 0 6.2499e-05 0 6.25e-05 0 6.2999e-05 0 6.3e-05 0 6.3499e-05 0 6.35e-05 0 6.3999e-05 0 6.4e-05 1.8 6.4499e-05 1.8 6.45e-05 1.8 6.4999e-05 1.8 6.5e-05 1.8 6.5499e-05 1.8 6.55e-05 1.8 6.5999e-05 1.8 6.6e-05 1.8 6.6499e-05 1.8 6.65e-05 1.8 6.6999e-05 1.8 6.7e-05 1.8 6.7499e-05 1.8 6.75e-05 1.8 6.7999e-05 1.8 6.8e-05 1.8 6.8499e-05 1.8 6.85e-05 1.8 6.8999e-05 1.8 6.9e-05 1.8 6.9499e-05 1.8 6.95e-05 1.8 6.9999e-05 1.8 7e-05 1.8 7.0499e-05 1.8 7.05e-05 1.8 7.0999e-05 1.8 7.1e-05 1.8 7.1499e-05 1.8 7.15e-05 1.8 7.1999e-05 1.8 7.2e-05 1.8 7.2499e-05 1.8 7.25e-05 1.8 7.2999e-05 1.8 7.3e-05 1.8 7.3499e-05 1.8 7.35e-05 1.8 7.3999e-05 1.8 7.4e-05 1.8 7.4499e-05 1.8 7.45e-05 1.8 7.4999e-05 1.8 7.5e-05 1.8 7.5499e-05 1.8 7.55e-05 1.8 7.5999e-05 1.8 7.6e-05 1.8 7.6499e-05 1.8 7.65e-05 1.8 7.6999e-05 1.8 7.7e-05 1.8 7.7499e-05 1.8 7.75e-05 1.8 7.7999e-05 1.8 7.8e-05 1.8 7.8499e-05 1.8 7.85e-05 1.8 7.8999e-05 1.8 7.9e-05 1.8 7.9499e-05 1.8 7.95e-05 1.8 7.9999e-05 1.8 8e-05 1.8 8.0499e-05 1.8 8.05e-05 1.8 8.0999e-05 1.8 8.1e-05 1.8 8.1499e-05 1.8 8.15e-05 1.8 8.1999e-05 1.8 8.2e-05 1.8 8.2499e-05 1.8 8.25e-05 1.8 8.2999e-05 1.8 8.3e-05 1.8 8.3499e-05 1.8 8.35e-05 1.8 8.3999e-05 1.8 8.4e-05 1.8 8.4499e-05 1.8 8.45e-05 1.8 8.4999e-05 1.8 8.5e-05 1.8 8.5499e-05 1.8 8.55e-05 1.8 8.5999e-05 1.8 8.6e-05 1.8 8.6499e-05 1.8 8.65e-05 1.8 8.6999e-05 1.8 8.7e-05 1.8 8.7499e-05 1.8 8.75e-05 1.8 8.7999e-05 1.8 8.8e-05 1.8 8.8499e-05 1.8 8.85e-05 1.8 8.8999e-05 1.8 8.9e-05 1.8 8.9499e-05 1.8 8.95e-05 1.8 8.9999e-05 1.8 9e-05 1.8 9.0499e-05 1.8 9.05e-05 1.8 9.0999e-05 1.8 9.1e-05 1.8 9.1499e-05 1.8 9.15e-05 1.8 9.1999e-05 1.8 9.2e-05 1.8 9.2499e-05 1.8 9.25e-05 1.8 9.2999e-05 1.8 9.3e-05 1.8 9.3499e-05 1.8 9.35e-05 1.8 9.3999e-05 1.8 9.4e-05 1.8 9.4499e-05 1.8 9.45e-05 1.8 9.4999e-05 1.8 9.5e-05 1.8 9.5499e-05 1.8 9.55e-05 1.8 9.5999e-05 1.8 9.6e-05 1.8 9.6499e-05 1.8 9.65e-05 1.8 9.6999e-05 1.8 9.7e-05 1.8 9.7499e-05 1.8 9.75e-05 1.8 9.7999e-05 1.8 9.8e-05 1.8 9.8499e-05 1.8 9.85e-05 1.8 9.8999e-05 1.8 9.9e-05 1.8 9.9499e-05 1.8 9.95e-05 1.8 9.9999e-05 1.8 0.0001 1.8 0.000100499 1.8 0.0001005 1.8 0.000100999 1.8 0.000101 1.8 0.000101499 1.8 0.0001015 1.8 0.000101999 1.8 0.000102 1.8 0.000102499 1.8 0.0001025 1.8 0.000102999 1.8 0.000103 1.8 0.000103499 1.8 0.0001035 1.8 0.000103999 1.8 0.000104 1.8 0.000104499 1.8 0.0001045 1.8 0.000104999 1.8 0.000105 1.8 0.000105499 1.8 0.0001055 1.8 0.000105999 1.8 0.000106 1.8 0.000106499 1.8 0.0001065 1.8 0.000106999 1.8 0.000107 1.8 0.000107499 1.8 0.0001075 1.8 0.000107999 1.8 0.000108 1.8 0.000108499 1.8 0.0001085 1.8 0.000108999 1.8 0.000109 1.8 0.000109499 1.8 0.0001095 1.8 0.000109999 1.8 0.00011 1.8 0.000110499 1.8 0.0001105 1.8 0.000110999 1.8 0.000111 1.8 0.000111499 1.8 0.0001115 1.8 0.000111999 1.8 0.000112 1.8 0.000112499 1.8 0.0001125 1.8 0.000112999 1.8 0.000113 1.8 0.000113499 1.8 0.0001135 1.8 0.000113999 1.8 0.000114 1.8 0.000114499 1.8 0.0001145 1.8 0.000114999 1.8 0.000115 1.8 0.000115499 1.8 0.0001155 1.8 0.000115999 1.8 0.000116 1.8 0.000116499 1.8 0.0001165 1.8 0.000116999 1.8 0.000117 1.8 0.000117499 1.8 0.0001175 1.8 0.000117999 1.8 0.000118 1.8 0.000118499 1.8 0.0001185 1.8 0.000118999 1.8 0.000119 1.8 0.000119499 1.8 0.0001195 1.8 0.000119999 1.8 0.00012 1.8 0.000120499 1.8 0.0001205 1.8 0.000120999 1.8 0.000121 1.8 0.000121499 1.8 0.0001215 1.8 0.000121999 1.8 0.000122 1.8 0.000122499 1.8 0.0001225 1.8 0.000122999 1.8 0.000123 1.8 0.000123499 1.8 0.0001235 1.8 0.000123999 1.8 0.000124 1.8 0.000124499 1.8 0.0001245 1.8 0.000124999 1.8 0.000125 1.8 0.000125499 1.8 0.0001255 1.8 0.000125999 1.8 0.000126 1.8 0.000126499 1.8 0.0001265 1.8 0.000126999 1.8 0.000127 1.8 0.000127499 1.8 0.0001275 1.8 0.000128 1.8)
