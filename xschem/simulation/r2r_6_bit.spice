** sch_path: /home/j542yu/Documents/ece298a-msk-modem/xschem/r2r_6_bit.sch
**.subckt r2r_6_bit R2R_6_BIT_OUT VREF_L B[5],B[4],B[3],B[2],B[1],B[0]
*.opin R2R_6_BIT_OUT
*.ipin VREF_L
*.ipin B[5],B[4],B[3],B[2],B[1],B[0]
XR1 net1 net4 VREF_L ppolyf_u_3k r_width=2e-6 r_length=20e-6 m=1
XR2 net2 net1 VREF_L ppolyf_u_3k r_width=2e-6 r_length=20e-6 m=1
XR5 net7 net1 VREF_L ppolyf_u_3k r_width=2e-6 r_length=20e-6 m=1
XR6 B[1] net7 VREF_L ppolyf_u_3k r_width=2e-6 r_length=20e-6 m=1
XR3 net8 net2 VREF_L ppolyf_u_3k r_width=2e-6 r_length=20e-6 m=1
XR4 B[2] net8 VREF_L ppolyf_u_3k r_width=2e-6 r_length=20e-6 m=1
XR7 net3 net2 VREF_L ppolyf_u_3k r_width=2e-6 r_length=20e-6 m=1
XR8 net5 net3 VREF_L ppolyf_u_3k r_width=2e-6 r_length=20e-6 m=1
XR9 net9 net3 VREF_L ppolyf_u_3k r_width=2e-6 r_length=20e-6 m=1
XR10 B[3] net9 VREF_L ppolyf_u_3k r_width=2e-6 r_length=20e-6 m=1
XR13 net10 net4 VREF_L ppolyf_u_3k r_width=2e-6 r_length=20e-6 m=1
XR14 B[0] net10 VREF_L ppolyf_u_3k r_width=2e-6 r_length=20e-6 m=1
XR15 net4 net11 VREF_L ppolyf_u_3k r_width=2e-6 r_length=20e-6 m=1
XR16 net11 VREF_L VREF_L ppolyf_u_3k r_width=2e-6 r_length=20e-6 m=1
XR11 net6 net5 VREF_L ppolyf_u_3k r_width=2e-6 r_length=20e-6 m=1
XR12 net12 net5 VREF_L ppolyf_u_3k r_width=2e-6 r_length=20e-6 m=1
XR17 B[4] net12 VREF_L ppolyf_u_3k r_width=2e-6 r_length=20e-6 m=1
* tap: B[5:0] --> B[0]
* tap: B[5:0] --> B[1]
* tap: B[5:0] --> B[2]
* tap: B[5:0] --> B[3]
* tap: B[5:0] --> B[4]
XR18 R2R_6_BIT_OUT net6 VREF_L ppolyf_u_3k r_width=2e-6 r_length=20e-6 m=1
XR19 net13 net6 VREF_L ppolyf_u_3k r_width=2e-6 r_length=20e-6 m=1
XR20 B[5] net13 VREF_L ppolyf_u_3k r_width=2e-6 r_length=20e-6 m=1
* tap: B[5:0] --> B[5]
**.ends
.end
