** sch_path: /home/j542yu/Documents/ece298a-msk-modem/xschem/full_r2r.sch
**.subckt full_r2r FULL_R2R_OUT VREF_L B_R[7],B_R[6],B_R[5],B_R[4],B_R[3],B_R[2],B_R[1],B_R[0]
*.opin FULL_R2R_OUT
*.ipin VREF_L
*.ipin B_R[7],B_R[6],B_R[5],B_R[4],B_R[3],B_R[2],B_R[1],B_R[0]
XR1 net1 net4 VREF_L ppolyf_u_3k r_width=2e-6 r_length=20e-6 m=1
XR2 net2 net1 VREF_L ppolyf_u_3k r_width=2e-6 r_length=20e-6 m=1
XR5 net7 net1 VREF_L ppolyf_u_3k r_width=2e-6 r_length=20e-6 m=1
XR6 B_R[1] net7 VREF_L ppolyf_u_3k r_width=2e-6 r_length=20e-6 m=1
XR3 net8 net2 VREF_L ppolyf_u_3k r_width=2e-6 r_length=20e-6 m=1
XR4 B_R[2] net8 VREF_L ppolyf_u_3k r_width=2e-6 r_length=20e-6 m=1
XR7 net3 net2 VREF_L ppolyf_u_3k r_width=2e-6 r_length=20e-6 m=1
XR8 net5 net3 VREF_L ppolyf_u_3k r_width=2e-6 r_length=20e-6 m=1
XR9 net9 net3 VREF_L ppolyf_u_3k r_width=2e-6 r_length=20e-6 m=1
XR10 B_R[3] net9 VREF_L ppolyf_u_3k r_width=2e-6 r_length=20e-6 m=1
XR13 net10 net4 VREF_L ppolyf_u_3k r_width=2e-6 r_length=20e-6 m=1
XR14 B_R[0] net10 VREF_L ppolyf_u_3k r_width=2e-6 r_length=20e-6 m=1
XR15 net4 net11 VREF_L ppolyf_u_3k r_width=2e-6 r_length=20e-6 m=1
XR16 net11 VREF_L VREF_L ppolyf_u_3k r_width=2e-6 r_length=20e-6 m=1
XR11 net6 net5 VREF_L ppolyf_u_3k r_width=2e-6 r_length=20e-6 m=1
XR12 net12 net5 VREF_L ppolyf_u_3k r_width=2e-6 r_length=20e-6 m=1
XR17 B_R[4] net12 VREF_L ppolyf_u_3k r_width=2e-6 r_length=20e-6 m=1
* tap: B_R[7:0] --> B_R[0]
* tap: B_R[7:0] --> B_R[1]
* tap: B_R[7:0] --> B_R[2]
* tap: B_R[7:0] --> B_R[3]
* tap: B_R[7:0] --> B_R[4]
XR18 net13 net6 VREF_L ppolyf_u_3k r_width=2e-6 r_length=20e-6 m=1
XR19 net15 net6 VREF_L ppolyf_u_3k r_width=2e-6 r_length=20e-6 m=1
XR20 B_R[5] net15 VREF_L ppolyf_u_3k r_width=2e-6 r_length=20e-6 m=1
XR21 net14 net13 VREF_L ppolyf_u_3k r_width=2e-6 r_length=20e-6 m=1
XR22 net16 net13 VREF_L ppolyf_u_3k r_width=2e-6 r_length=20e-6 m=1
XR23 B_R[6] net16 VREF_L ppolyf_u_3k r_width=2e-6 r_length=20e-6 m=1
* tap: B_R[7:0] --> B_R[5]
* tap: B_R[7:0] --> B_R[6]
XR24 FULL_R2R_OUT net14 VREF_L ppolyf_u_3k r_width=2e-6 r_length=20e-6 m=1
* tap: B_R[7:0] --> B_R[7]
XR25 net17 net14 VREF_L ppolyf_u_3k r_width=2e-6 r_length=20e-6 m=1
XR26 B_R[7] net17 VREF_L ppolyf_u_3k r_width=2e-6 r_length=20e-6 m=1
**.ends
.end
