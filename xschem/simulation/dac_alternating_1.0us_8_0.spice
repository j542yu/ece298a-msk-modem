* Automatically generated DAC stimulus: alternating
* DAC bits: 8
* Number of code intervals: 32
* Dwell: 1e-06 s
* Edge duration: 1e-09 s
* Simulation duration: 3.2e-05 s

V1 B[0] GND PWL(0 3.3 9.99e-07 3.3 1e-06 0 1.999e-06 0 2e-06 3.3 2.999e-06 3.3 3e-06 0 3.999e-06 0 4e-06 3.3 4.999e-06 3.3 5e-06 0 5.999e-06 0 6e-06 3.3 6.999e-06 3.3 7e-06 0 7.999e-06 0 8e-06 3.3 8.999e-06 3.3 9e-06 0 9.999e-06 0 1e-05 3.3 1.0999e-05 3.3 1.1e-05 0 1.1999e-05 0 1.2e-05 3.3 1.2999e-05 3.3 1.3e-05 0 1.3999e-05 0 1.4e-05 3.3 1.4999e-05 3.3 1.5e-05 0 1.5999e-05 0 1.6e-05 3.3 1.6999e-05 3.3 1.7e-05 0 1.7999e-05 0 1.8e-05 3.3 1.8999e-05 3.3 1.9e-05 0 1.9999e-05 0 2e-05 3.3 2.0999e-05 3.3 2.1e-05 0 2.1999e-05 0 2.2e-05 3.3 2.2999e-05 3.3 2.3e-05 0 2.3999e-05 0 2.4e-05 3.3 2.4999e-05 3.3 2.5e-05 0 2.5999e-05 0 2.6e-05 3.3 2.6999e-05 3.3 2.7e-05 0 2.7999e-05 0 2.8e-05 3.3 2.8999e-05 3.3 2.9e-05 0 2.9999e-05 0 3e-05 3.3 3.0999e-05 3.3 3.1e-05 0 3.2e-05 0)
V2 B[1] GND PWL(0 0 9.99e-07 0 1e-06 3.3 1.999e-06 3.3 2e-06 0 2.999e-06 0 3e-06 3.3 3.999e-06 3.3 4e-06 0 4.999e-06 0 5e-06 3.3 5.999e-06 3.3 6e-06 0 6.999e-06 0 7e-06 3.3 7.999e-06 3.3 8e-06 0 8.999e-06 0 9e-06 3.3 9.999e-06 3.3 1e-05 0 1.0999e-05 0 1.1e-05 3.3 1.1999e-05 3.3 1.2e-05 0 1.2999e-05 0 1.3e-05 3.3 1.3999e-05 3.3 1.4e-05 0 1.4999e-05 0 1.5e-05 3.3 1.5999e-05 3.3 1.6e-05 0 1.6999e-05 0 1.7e-05 3.3 1.7999e-05 3.3 1.8e-05 0 1.8999e-05 0 1.9e-05 3.3 1.9999e-05 3.3 2e-05 0 2.0999e-05 0 2.1e-05 3.3 2.1999e-05 3.3 2.2e-05 0 2.2999e-05 0 2.3e-05 3.3 2.3999e-05 3.3 2.4e-05 0 2.4999e-05 0 2.5e-05 3.3 2.5999e-05 3.3 2.6e-05 0 2.6999e-05 0 2.7e-05 3.3 2.7999e-05 3.3 2.8e-05 0 2.8999e-05 0 2.9e-05 3.3 2.9999e-05 3.3 3e-05 0 3.0999e-05 0 3.1e-05 3.3 3.2e-05 3.3)
V3 B[2] GND PWL(0 3.3 9.99e-07 3.3 1e-06 0 1.999e-06 0 2e-06 3.3 2.999e-06 3.3 3e-06 0 3.999e-06 0 4e-06 3.3 4.999e-06 3.3 5e-06 0 5.999e-06 0 6e-06 3.3 6.999e-06 3.3 7e-06 0 7.999e-06 0 8e-06 3.3 8.999e-06 3.3 9e-06 0 9.999e-06 0 1e-05 3.3 1.0999e-05 3.3 1.1e-05 0 1.1999e-05 0 1.2e-05 3.3 1.2999e-05 3.3 1.3e-05 0 1.3999e-05 0 1.4e-05 3.3 1.4999e-05 3.3 1.5e-05 0 1.5999e-05 0 1.6e-05 3.3 1.6999e-05 3.3 1.7e-05 0 1.7999e-05 0 1.8e-05 3.3 1.8999e-05 3.3 1.9e-05 0 1.9999e-05 0 2e-05 3.3 2.0999e-05 3.3 2.1e-05 0 2.1999e-05 0 2.2e-05 3.3 2.2999e-05 3.3 2.3e-05 0 2.3999e-05 0 2.4e-05 3.3 2.4999e-05 3.3 2.5e-05 0 2.5999e-05 0 2.6e-05 3.3 2.6999e-05 3.3 2.7e-05 0 2.7999e-05 0 2.8e-05 3.3 2.8999e-05 3.3 2.9e-05 0 2.9999e-05 0 3e-05 3.3 3.0999e-05 3.3 3.1e-05 0 3.2e-05 0)
V4 B[3] GND PWL(0 0 9.99e-07 0 1e-06 3.3 1.999e-06 3.3 2e-06 0 2.999e-06 0 3e-06 3.3 3.999e-06 3.3 4e-06 0 4.999e-06 0 5e-06 3.3 5.999e-06 3.3 6e-06 0 6.999e-06 0 7e-06 3.3 7.999e-06 3.3 8e-06 0 8.999e-06 0 9e-06 3.3 9.999e-06 3.3 1e-05 0 1.0999e-05 0 1.1e-05 3.3 1.1999e-05 3.3 1.2e-05 0 1.2999e-05 0 1.3e-05 3.3 1.3999e-05 3.3 1.4e-05 0 1.4999e-05 0 1.5e-05 3.3 1.5999e-05 3.3 1.6e-05 0 1.6999e-05 0 1.7e-05 3.3 1.7999e-05 3.3 1.8e-05 0 1.8999e-05 0 1.9e-05 3.3 1.9999e-05 3.3 2e-05 0 2.0999e-05 0 2.1e-05 3.3 2.1999e-05 3.3 2.2e-05 0 2.2999e-05 0 2.3e-05 3.3 2.3999e-05 3.3 2.4e-05 0 2.4999e-05 0 2.5e-05 3.3 2.5999e-05 3.3 2.6e-05 0 2.6999e-05 0 2.7e-05 3.3 2.7999e-05 3.3 2.8e-05 0 2.8999e-05 0 2.9e-05 3.3 2.9999e-05 3.3 3e-05 0 3.0999e-05 0 3.1e-05 3.3 3.2e-05 3.3)
V5 B[4] GND PWL(0 3.3 9.99e-07 3.3 1e-06 0 1.999e-06 0 2e-06 3.3 2.999e-06 3.3 3e-06 0 3.999e-06 0 4e-06 3.3 4.999e-06 3.3 5e-06 0 5.999e-06 0 6e-06 3.3 6.999e-06 3.3 7e-06 0 7.999e-06 0 8e-06 3.3 8.999e-06 3.3 9e-06 0 9.999e-06 0 1e-05 3.3 1.0999e-05 3.3 1.1e-05 0 1.1999e-05 0 1.2e-05 3.3 1.2999e-05 3.3 1.3e-05 0 1.3999e-05 0 1.4e-05 3.3 1.4999e-05 3.3 1.5e-05 0 1.5999e-05 0 1.6e-05 3.3 1.6999e-05 3.3 1.7e-05 0 1.7999e-05 0 1.8e-05 3.3 1.8999e-05 3.3 1.9e-05 0 1.9999e-05 0 2e-05 3.3 2.0999e-05 3.3 2.1e-05 0 2.1999e-05 0 2.2e-05 3.3 2.2999e-05 3.3 2.3e-05 0 2.3999e-05 0 2.4e-05 3.3 2.4999e-05 3.3 2.5e-05 0 2.5999e-05 0 2.6e-05 3.3 2.6999e-05 3.3 2.7e-05 0 2.7999e-05 0 2.8e-05 3.3 2.8999e-05 3.3 2.9e-05 0 2.9999e-05 0 3e-05 3.3 3.0999e-05 3.3 3.1e-05 0 3.2e-05 0)
V6 B[5] GND PWL(0 0 9.99e-07 0 1e-06 3.3 1.999e-06 3.3 2e-06 0 2.999e-06 0 3e-06 3.3 3.999e-06 3.3 4e-06 0 4.999e-06 0 5e-06 3.3 5.999e-06 3.3 6e-06 0 6.999e-06 0 7e-06 3.3 7.999e-06 3.3 8e-06 0 8.999e-06 0 9e-06 3.3 9.999e-06 3.3 1e-05 0 1.0999e-05 0 1.1e-05 3.3 1.1999e-05 3.3 1.2e-05 0 1.2999e-05 0 1.3e-05 3.3 1.3999e-05 3.3 1.4e-05 0 1.4999e-05 0 1.5e-05 3.3 1.5999e-05 3.3 1.6e-05 0 1.6999e-05 0 1.7e-05 3.3 1.7999e-05 3.3 1.8e-05 0 1.8999e-05 0 1.9e-05 3.3 1.9999e-05 3.3 2e-05 0 2.0999e-05 0 2.1e-05 3.3 2.1999e-05 3.3 2.2e-05 0 2.2999e-05 0 2.3e-05 3.3 2.3999e-05 3.3 2.4e-05 0 2.4999e-05 0 2.5e-05 3.3 2.5999e-05 3.3 2.6e-05 0 2.6999e-05 0 2.7e-05 3.3 2.7999e-05 3.3 2.8e-05 0 2.8999e-05 0 2.9e-05 3.3 2.9999e-05 3.3 3e-05 0 3.0999e-05 0 3.1e-05 3.3 3.2e-05 3.3)
V7 B[6] GND PWL(0 3.3 9.99e-07 3.3 1e-06 0 1.999e-06 0 2e-06 3.3 2.999e-06 3.3 3e-06 0 3.999e-06 0 4e-06 3.3 4.999e-06 3.3 5e-06 0 5.999e-06 0 6e-06 3.3 6.999e-06 3.3 7e-06 0 7.999e-06 0 8e-06 3.3 8.999e-06 3.3 9e-06 0 9.999e-06 0 1e-05 3.3 1.0999e-05 3.3 1.1e-05 0 1.1999e-05 0 1.2e-05 3.3 1.2999e-05 3.3 1.3e-05 0 1.3999e-05 0 1.4e-05 3.3 1.4999e-05 3.3 1.5e-05 0 1.5999e-05 0 1.6e-05 3.3 1.6999e-05 3.3 1.7e-05 0 1.7999e-05 0 1.8e-05 3.3 1.8999e-05 3.3 1.9e-05 0 1.9999e-05 0 2e-05 3.3 2.0999e-05 3.3 2.1e-05 0 2.1999e-05 0 2.2e-05 3.3 2.2999e-05 3.3 2.3e-05 0 2.3999e-05 0 2.4e-05 3.3 2.4999e-05 3.3 2.5e-05 0 2.5999e-05 0 2.6e-05 3.3 2.6999e-05 3.3 2.7e-05 0 2.7999e-05 0 2.8e-05 3.3 2.8999e-05 3.3 2.9e-05 0 2.9999e-05 0 3e-05 3.3 3.0999e-05 3.3 3.1e-05 0 3.2e-05 0)
V8 B[7] GND PWL(0 0 9.99e-07 0 1e-06 3.3 1.999e-06 3.3 2e-06 0 2.999e-06 0 3e-06 3.3 3.999e-06 3.3 4e-06 0 4.999e-06 0 5e-06 3.3 5.999e-06 3.3 6e-06 0 6.999e-06 0 7e-06 3.3 7.999e-06 3.3 8e-06 0 8.999e-06 0 9e-06 3.3 9.999e-06 3.3 1e-05 0 1.0999e-05 0 1.1e-05 3.3 1.1999e-05 3.3 1.2e-05 0 1.2999e-05 0 1.3e-05 3.3 1.3999e-05 3.3 1.4e-05 0 1.4999e-05 0 1.5e-05 3.3 1.5999e-05 3.3 1.6e-05 0 1.6999e-05 0 1.7e-05 3.3 1.7999e-05 3.3 1.8e-05 0 1.8999e-05 0 1.9e-05 3.3 1.9999e-05 3.3 2e-05 0 2.0999e-05 0 2.1e-05 3.3 2.1999e-05 3.3 2.2e-05 0 2.2999e-05 0 2.3e-05 3.3 2.3999e-05 3.3 2.4e-05 0 2.4999e-05 0 2.5e-05 3.3 2.5999e-05 3.3 2.6e-05 0 2.6999e-05 0 2.7e-05 3.3 2.7999e-05 3.3 2.8e-05 0 2.8999e-05 0 2.9e-05 3.3 2.9999e-05 3.3 3e-05 0 3.0999e-05 0 3.1e-05 3.3 3.2e-05 3.3)
