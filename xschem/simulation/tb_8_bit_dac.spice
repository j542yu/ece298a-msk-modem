** sch_path: /home/j542yu/Documents/ece298a-msk-modem/xschem/tb_8_bit_dac.sch
**.subckt tb_8_bit_dac B[4],B[3],B[2],B[1],B[0] T[6],T[5],T[4],T[3],T[2],T[1],T[0]
*+ B_R[7],B_R[6],B_R[5],B_R[4],B_R[3],B_R[2],B_R[1],B_R[0] DAC_OUT_5_3_SEG DAC_OUT_FULL_R2R B[5],B[4],B[3],B[2],B[1],B[0] T[3],T[2],T[1],T[0]
*.ipin B[4],B[3],B[2],B[1],B[0]
*.ipin T[6],T[5],T[4],T[3],T[2],T[1],T[0]
*.ipin B_R[7],B_R[6],B_R[5],B_R[4],B_R[3],B_R[2],B_R[1],B_R[0]
*.ipin DAC_OUT_5_3_SEG
*.ipin DAC_OUT_FULL_R2R
*.ipin B[5],B[4],B[3],B[2],B[1],B[0]
*.ipin T[3],T[2],T[1],T[0]
x1 B[5] B[4] B[3] B[2] B[1] B[0] DAC_OUT_6_2_SEG T[3] T[2] T[1] T[0] 6_2_dac
x2 B_R[7] B_R[6] B_R[5] B_R[4] B_R[3] B_R[2] B_R[1] B_R[0] GND DAC_OUT_FULL_R2R 8_bit_r2r
x3 B[4] B[3] B[2] B[1] B[0] T[6] T[5] T[4] T[3] T[2] T[1] T[0] DAC_OUT_5_3_SEG 5_3_dac
**** begin user architecture code

.include design.ngspice
.lib sm141064.ngspice ff
.lib sm141064.ngspice res_ff

.option wnflag=1

.control
    tran 10n 256u
    write tb_8_bit_dac.raw
.endc

.include dac_sine_1.0us_5_3.spice

.include dac_sine_1.0us_8_0.spice

**** end user architecture code
**.ends

* expanding   symbol:  6_2_dac.sym # of pins=3
** sym_path: /home/j542yu/Documents/ece298a-msk-modem/xschem/6_2_dac.sym
** sch_path: /home/j542yu/Documents/ece298a-msk-modem/xschem/6_2_dac.sch
.subckt 6_2_dac B[5] B[4] B[3] B[2] B[1] B[0] 6_2_DAC_OUT T[3] T[2] T[1] T[0]
*.ipin B[5],B[4],B[3],B[2],B[1],B[0]
*.ipin T[3],T[2],T[1],T[0]
*.opin 6_2_DAC_OUT
x1 6_2_DAC_OUT GND T[3] T[2] T[1] T[0] 2_bit_therm
x2 B[5] B[4] B[3] B[2] B[1] B[0] GND 6_2_DAC_OUT 6_bit_r2r
.ends

* expanding   symbol:  /home/j542yu/Documents/ece298a-msk-modem/xschem/8_bit_r2r.sym # of pins=3
** sym_path: /home/j542yu/Documents/ece298a-msk-modem/xschem/8_bit_r2r.sym
** sch_path: /home/j542yu/Documents/ece298a-msk-modem/xschem/8_bit_r2r.sch
.subckt 8_bit_r2r B_R[7] B_R[6] B_R[5] B_R[4] B_R[3] B_R[2] B_R[1] B_R[0] VREF_L FULL_R2R_OUT
*.opin FULL_R2R_OUT
*.ipin VREF_L
*.ipin B_R[7],B_R[6],B_R[5],B_R[4],B_R[3],B_R[2],B_R[1],B_R[0]
XR1 net1 net4 VREF_L ppolyf_u_3k r_width=2e-6 r_length=20e-6 m=1
XR2 net2 net1 VREF_L ppolyf_u_3k r_width=2e-6 r_length=20e-6 m=1
XR5 net7 net1 VREF_L ppolyf_u_3k r_width=2e-6 r_length=20e-6 m=1
XR6 B_R[1] net7 VREF_L ppolyf_u_3k r_width=2e-6 r_length=20e-6 m=1
XR3 net8 net2 VREF_L ppolyf_u_3k r_width=2e-6 r_length=20e-6 m=1
XR4 B_R[2] net8 VREF_L ppolyf_u_3k r_width=2e-6 r_length=20e-6 m=1
XR7 net3 net2 VREF_L ppolyf_u_3k r_width=2e-6 r_length=20e-6 m=1
XR8 net5 net3 VREF_L ppolyf_u_3k r_width=2e-6 r_length=20e-6 m=1
XR9 net9 net3 VREF_L ppolyf_u_3k r_width=2e-6 r_length=20e-6 m=1
XR10 B_R[3] net9 VREF_L ppolyf_u_3k r_width=2e-6 r_length=20e-6 m=1
XR13 net10 net4 VREF_L ppolyf_u_3k r_width=2e-6 r_length=20e-6 m=1
XR14 B_R[0] net10 VREF_L ppolyf_u_3k r_width=2e-6 r_length=20e-6 m=1
XR15 net4 net11 VREF_L ppolyf_u_3k r_width=2e-6 r_length=20e-6 m=1
XR16 net11 VREF_L VREF_L ppolyf_u_3k r_width=2e-6 r_length=20e-6 m=1
XR11 net6 net5 VREF_L ppolyf_u_3k r_width=2e-6 r_length=20e-6 m=1
XR12 net12 net5 VREF_L ppolyf_u_3k r_width=2e-6 r_length=20e-6 m=1
XR17 B_R[4] net12 VREF_L ppolyf_u_3k r_width=2e-6 r_length=20e-6 m=1
* tap: B_R[7:0] --> B_R[0]
* tap: B_R[7:0] --> B_R[1]
* tap: B_R[7:0] --> B_R[2]
* tap: B_R[7:0] --> B_R[3]
* tap: B_R[7:0] --> B_R[4]
XR18 net13 net6 VREF_L ppolyf_u_3k r_width=2e-6 r_length=20e-6 m=1
XR19 net15 net6 VREF_L ppolyf_u_3k r_width=2e-6 r_length=20e-6 m=1
XR20 B_R[5] net15 VREF_L ppolyf_u_3k r_width=2e-6 r_length=20e-6 m=1
XR21 net14 net13 VREF_L ppolyf_u_3k r_width=2e-6 r_length=20e-6 m=1
XR22 net16 net13 VREF_L ppolyf_u_3k r_width=2e-6 r_length=20e-6 m=1
XR23 B_R[6] net16 VREF_L ppolyf_u_3k r_width=2e-6 r_length=20e-6 m=1
* tap: B_R[7:0] --> B_R[5]
* tap: B_R[7:0] --> B_R[6]
XR24 FULL_R2R_OUT net14 VREF_L ppolyf_u_3k r_width=2e-6 r_length=20e-6 m=1
* tap: B_R[7:0] --> B_R[7]
XR25 net17 net14 VREF_L ppolyf_u_3k r_width=2e-6 r_length=20e-6 m=1
XR26 B_R[7] net17 VREF_L ppolyf_u_3k r_width=2e-6 r_length=20e-6 m=1
.ends

* expanding   symbol:  /home/j542yu/Documents/ece298a-msk-modem/xschem/5_3_dac.sym # of pins=3
** sym_path: /home/j542yu/Documents/ece298a-msk-modem/xschem/5_3_dac.sym
** sch_path: /home/j542yu/Documents/ece298a-msk-modem/xschem/5_3_dac.sch
.subckt 5_3_dac B[4] B[3] B[2] B[1] B[0] T[6] T[5] T[4] T[3] T[2] T[1] T[0] DAC_OUT
*.opin DAC_OUT
*.ipin B[4],B[3],B[2],B[1],B[0]
*.ipin T[6],T[5],T[4],T[3],T[2],T[1],T[0]
x1 GND GND GND GND GND B[4] DAC_OUT 5_bit_r2r
x2 DAC_OUT T[6] GND GND GND GND GND GND GND 3_bit_therm
.ends

* expanding   symbol:  /home/j542yu/Documents/ece298a-msk-modem/xschem/2_bit_therm.sym # of pins=3
** sym_path: /home/j542yu/Documents/ece298a-msk-modem/xschem/2_bit_therm.sym
** sch_path: /home/j542yu/Documents/ece298a-msk-modem/xschem/2_bit_therm.sch
.subckt 2_bit_therm THERM_2_BIT_IO VREF_L T[3] T[2] T[1] T[0]
*.ipin T[3],T[2],T[1],T[0]
*.iopin THERM_2_BIT_IO
*.ipin VREF_L
XR11 net1 THERM_2_BIT_IO VREF_L ppolyf_u_3k r_width=2e-6 r_length=20e-6 m=1
XR12 T[0] net1 VREF_L ppolyf_u_3k r_width=2e-6 r_length=20e-6 m=1
XR19 net2 THERM_2_BIT_IO VREF_L ppolyf_u_3k r_width=2e-6 r_length=20e-6 m=1
XR20 T[1] net2 VREF_L ppolyf_u_3k r_width=2e-6 r_length=20e-6 m=1
XR21 net3 THERM_2_BIT_IO VREF_L ppolyf_u_3k r_width=2e-6 r_length=20e-6 m=1
XR22 T[2] net3 VREF_L ppolyf_u_3k r_width=2e-6 r_length=20e-6 m=1
XR17 net4 THERM_2_BIT_IO VREF_L ppolyf_u_3k r_width=2e-6 r_length=20e-6 m=1
XR18 T[3] net4 VREF_L ppolyf_u_3k r_width=2e-6 r_length=20e-6 m=1
* tap: T[3:0] --> T[0]
* tap: T[3:0] --> T[1]
* tap: T[3:0] --> T[2]
* tap: T[3:0] --> T[3]
.ends

* expanding   symbol:  /home/j542yu/Documents/ece298a-msk-modem/xschem/6_bit_r2r.sym # of pins=3
** sym_path: /home/j542yu/Documents/ece298a-msk-modem/xschem/6_bit_r2r.sym
** sch_path: /home/j542yu/Documents/ece298a-msk-modem/xschem/6_bit_r2r.sch
.subckt 6_bit_r2r B[5] B[4] B[3] B[2] B[1] B[0] VREF_L R2R_6_BIT_OUT
*.opin R2R_6_BIT_OUT
*.ipin VREF_L
*.ipin B[5],B[4],B[3],B[2],B[1],B[0]
XR1 net1 net4 VREF_L ppolyf_u_3k r_width=2e-6 r_length=20e-6 m=1
XR2 net2 net1 VREF_L ppolyf_u_3k r_width=2e-6 r_length=20e-6 m=1
XR5 net7 net1 VREF_L ppolyf_u_3k r_width=2e-6 r_length=20e-6 m=1
XR6 B[1] net7 VREF_L ppolyf_u_3k r_width=2e-6 r_length=20e-6 m=1
XR3 net8 net2 VREF_L ppolyf_u_3k r_width=2e-6 r_length=20e-6 m=1
XR4 B[2] net8 VREF_L ppolyf_u_3k r_width=2e-6 r_length=20e-6 m=1
XR7 net3 net2 VREF_L ppolyf_u_3k r_width=2e-6 r_length=20e-6 m=1
XR8 net5 net3 VREF_L ppolyf_u_3k r_width=2e-6 r_length=20e-6 m=1
XR9 net9 net3 VREF_L ppolyf_u_3k r_width=2e-6 r_length=20e-6 m=1
XR10 B[3] net9 VREF_L ppolyf_u_3k r_width=2e-6 r_length=20e-6 m=1
XR13 net10 net4 VREF_L ppolyf_u_3k r_width=2e-6 r_length=20e-6 m=1
XR14 B[0] net10 VREF_L ppolyf_u_3k r_width=2e-6 r_length=20e-6 m=1
XR15 net4 net11 VREF_L ppolyf_u_3k r_width=2e-6 r_length=20e-6 m=1
XR16 net11 VREF_L VREF_L ppolyf_u_3k r_width=2e-6 r_length=20e-6 m=1
XR11 net6 net5 VREF_L ppolyf_u_3k r_width=2e-6 r_length=20e-6 m=1
XR12 net12 net5 VREF_L ppolyf_u_3k r_width=2e-6 r_length=20e-6 m=1
XR17 B[4] net12 VREF_L ppolyf_u_3k r_width=2e-6 r_length=20e-6 m=1
* tap: B[5:0] --> B[0]
* tap: B[5:0] --> B[1]
* tap: B[5:0] --> B[2]
* tap: B[5:0] --> B[3]
* tap: B[5:0] --> B[4]
XR18 R2R_6_BIT_OUT net6 VREF_L ppolyf_u_3k r_width=2e-6 r_length=20e-6 m=1
XR19 net13 net6 VREF_L ppolyf_u_3k r_width=2e-6 r_length=20e-6 m=1
XR20 B[5] net13 VREF_L ppolyf_u_3k r_width=2e-6 r_length=20e-6 m=1
* tap: B[5:0] --> B[5]
.ends

* expanding   symbol:  5_bit_r2r.sym # of pins=3
** sym_path: /home/j542yu/Documents/ece298a-msk-modem/xschem/5_bit_r2r.sym
** sch_path: /home/j542yu/Documents/ece298a-msk-modem/xschem/5_bit_r2r.sch
.subckt 5_bit_r2r B[4] B[3] B[2] B[1] B[0] VREF_L R2R_5_BIT_OUT
*.opin R2R_5_BIT_OUT
*.ipin VREF_L
*.ipin B[4],B[3],B[2],B[1],B[0]
XR1 net1 net4 VREF_L ppolyf_u_3k r_width=2e-6 r_length=20e-6 m=1
XR2 net2 net1 VREF_L ppolyf_u_3k r_width=2e-6 r_length=20e-6 m=1
XR5 net6 net1 VREF_L ppolyf_u_3k r_width=2e-6 r_length=20e-6 m=1
XR6 B[1] net6 VREF_L ppolyf_u_3k r_width=2e-6 r_length=20e-6 m=1
XR3 net7 net2 VREF_L ppolyf_u_3k r_width=2e-6 r_length=20e-6 m=1
XR4 B[2] net7 VREF_L ppolyf_u_3k r_width=2e-6 r_length=20e-6 m=1
XR7 net3 net2 VREF_L ppolyf_u_3k r_width=2e-6 r_length=20e-6 m=1
XR8 net5 net3 VREF_L ppolyf_u_3k r_width=2e-6 r_length=20e-6 m=1
XR9 net8 net3 VREF_L ppolyf_u_3k r_width=2e-6 r_length=20e-6 m=1
XR10 B[3] net8 VREF_L ppolyf_u_3k r_width=2e-6 r_length=20e-6 m=1
XR13 net9 net4 VREF_L ppolyf_u_3k r_width=2e-6 r_length=20e-6 m=1
XR14 B[0] net9 VREF_L ppolyf_u_3k r_width=2e-6 r_length=20e-6 m=1
XR15 net4 net10 VREF_L ppolyf_u_3k r_width=2e-6 r_length=20e-6 m=1
XR16 net10 VREF_L VREF_L ppolyf_u_3k r_width=2e-6 r_length=20e-6 m=1
XR11 R2R_5_BIT_OUT net5 VREF_L ppolyf_u_3k r_width=2e-6 r_length=20e-6 m=1
XR12 net11 net5 VREF_L ppolyf_u_3k r_width=2e-6 r_length=20e-6 m=1
XR17 B[4] net11 VREF_L ppolyf_u_3k r_width=2e-6 r_length=20e-6 m=1
* tap: B[4:0] --> B[0]
* tap: B[4:0] --> B[1]
* tap: B[4:0] --> B[2]
* tap: B[4:0] --> B[3]
* tap: B[4:0] --> B[4]
.ends

* expanding   symbol:  3_bit_therm.sym # of pins=3
** sym_path: /home/j542yu/Documents/ece298a-msk-modem/xschem/3_bit_therm.sym
** sch_path: /home/j542yu/Documents/ece298a-msk-modem/xschem/3_bit_therm.sch
.subckt 3_bit_therm THERM_3_BIT_IO VREF_L T[6] T[5] T[4] T[3] T[2] T[1] T[0]
*.ipin T[6],T[5],T[4],T[3],T[2],T[1],T[0]
*.iopin THERM_3_BIT_IO
*.ipin VREF_L
XR11 net1 THERM_3_BIT_IO VREF_L ppolyf_u_3k r_width=2e-6 r_length=20e-6 m=1
XR12 T[0] net1 VREF_L ppolyf_u_3k r_width=2e-6 r_length=20e-6 m=1
XR19 net2 THERM_3_BIT_IO VREF_L ppolyf_u_3k r_width=2e-6 r_length=20e-6 m=1
XR20 T[1] net2 VREF_L ppolyf_u_3k r_width=2e-6 r_length=20e-6 m=1
XR21 net3 THERM_3_BIT_IO VREF_L ppolyf_u_3k r_width=2e-6 r_length=20e-6 m=1
XR22 T[2] net3 VREF_L ppolyf_u_3k r_width=2e-6 r_length=20e-6 m=1
XR17 net4 THERM_3_BIT_IO VREF_L ppolyf_u_3k r_width=2e-6 r_length=20e-6 m=1
XR18 T[3] net4 VREF_L ppolyf_u_3k r_width=2e-6 r_length=20e-6 m=1
XR23 net5 THERM_3_BIT_IO VREF_L ppolyf_u_3k r_width=2e-6 r_length=20e-6 m=1
XR24 T[4] net5 VREF_L ppolyf_u_3k r_width=2e-6 r_length=20e-6 m=1
XR25 net6 THERM_3_BIT_IO VREF_L ppolyf_u_3k r_width=2e-6 r_length=20e-6 m=1
XR26 T[5] net6 VREF_L ppolyf_u_3k r_width=2e-6 r_length=20e-6 m=1
XR27 net7 THERM_3_BIT_IO VREF_L ppolyf_u_3k r_width=2e-6 r_length=20e-6 m=1
XR28 T[6] net7 VREF_L ppolyf_u_3k r_width=2e-6 r_length=20e-6 m=1
* tap: T[6:0] --> T[0]
* tap: T[6:0] --> T[1]
* tap: T[6:0] --> T[2]
* tap: T[6:0] --> T[3]
* tap: T[6:0] --> T[4]
* tap: T[6:0] --> T[5]
* tap: T[6:0] --> T[6]
.ends

.GLOBAL GND
.end
