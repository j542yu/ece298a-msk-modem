* mixed signal simulation using Verilator and d_cosim
* Edited SPICE exported by Xschem to avoid brackets in node names

*x2 DAC_SCH_OUT b4 b3 b2 b1 b0 t6 t5 t4 t3 t2 t1 t0 0 dac_5_3
**** begin user architecture code

.include /usr/local/share/pdk/gf180mcuD/libs.tech/ngspice/design.ngspice
.lib /usr/local/share/pdk/gf180mcuD/libs.tech/ngspice/sm141064.ngspice typical
.lib /usr/local/share/pdk/gf180mcuD/libs.tech/ngspice/sm141064.ngspice res_typical

.include ../modulator_5_3_stimuli.spice

.option wnflag=1

.control
    tran 1n 15us
    edisplay
    eprint b4 b3 b2 b1 b0 t6 t5 t4 t3 t2 t1 t0
    write mixed.raw
.endc

adut [ clk rst_n enable in ] [ b4 b3 b2 b1 b0 t6 t5 t4 t3 t2 t1 t0 ] null
+ dut
.model dut d_cosim simulation="modulate_5_3.so"
**** end user architecture code
**.ends

* expanding   symbol:  dac_5_3.sym # of pins=4
** sym_path: /home/j542yu/Documents/ece298a-msk-modem/xschem/dac_5_3.sym
** sch_path: /home/j542yu/Documents/ece298a-msk-modem/xschem/dac_5_3.sch
.subckt dac_5_3 DAC_OUT B[4] B[3] B[2] B[1] B[0] T[6] T[5] T[4] T[3] T[2] T[1] T[0] VGND
*.ipin B[4],B[3],B[2],B[1],B[0]
*.ipin T[6],T[5],T[4],T[3],T[2],T[1],T[0]
*.opin DAC_OUT
*.iopin VGND
x1 net2 net1 B[0] VGND dac_sub_r2r
x2 net3 net2 B[1] VGND dac_sub_r2r
x3 net4 net3 B[2] VGND dac_sub_r2r
x4 net5 net4 B[3] VGND dac_sub_r2r
x5 DAC_OUT net5 B[4] VGND dac_sub_r2r
* tap: B[4:0] --> B[0]
* tap: B[4:0] --> B[1]
* tap: B[4:0] --> B[2]
* tap: B[4:0] --> B[3]
* tap: B[4:0] --> B[4]
x6 DAC_OUT T[0] VGND dac_sub_therm
x7 DAC_OUT T[1] VGND dac_sub_therm
x8 DAC_OUT T[2] VGND dac_sub_therm
x9 DAC_OUT T[3] VGND dac_sub_therm
x10 DAC_OUT T[4] VGND dac_sub_therm
x11 DAC_OUT T[5] VGND dac_sub_therm
x12 DAC_OUT T[6] VGND dac_sub_therm
* tap: T[6:0] --> T[0]
* tap: T[6:0] --> T[1]
* tap: T[6:0] --> T[2]
* tap: T[6:0] --> T[3]
* tap: T[6:0] --> T[4]
* tap: T[6:0] --> T[5]
* tap: T[6:0] --> T[6]
XR2 VGND net6 VGND ppolyf_u_1k r_width=2e-6 r_length=20e-6 m=1
XR3 net6 net1 VGND ppolyf_u_1k r_width=2e-6 r_length=20e-6 m=1
XR4 VGND VGND VGND ppolyf_u_1k r_width=2e-6 r_length=20e-6 m=1
XR5 VGND VGND VGND ppolyf_u_1k r_width=2e-6 r_length=20e-6 m=1
XR7 VGND VGND VGND ppolyf_u_1k r_width=2e-6 r_length=20e-6 m=1
.ends

* expanding   symbol:  dac_sub_r2r.sym # of pins=4
** sym_path: /home/j542yu/Documents/ece298a-msk-modem/xschem/dac_sub_r2r.sym
** sch_path: /home/j542yu/Documents/ece298a-msk-modem/xschem/dac_sub_r2r.sch
.subckt dac_sub_r2r R_node_out R_node_in in VGND
*.ipin in
*.iopin R_node_out
*.iopin R_node_in
*.iopin VGND
XR7 in net1 VGND ppolyf_u_1k r_width=2e-6 r_length=20e-6 m=1
XR1 net1 R_node_in VGND ppolyf_u_1k r_width=2e-6 r_length=20e-6 m=1
XR2 net2 R_node_in VGND ppolyf_u_1k r_width=2e-6 r_length=20e-6 m=1
XR3 R_node_out net2 VGND ppolyf_u_1k r_width=2e-6 r_length=20e-6 m=1
XR4 net3 R_node_in VGND ppolyf_u_1k r_width=2e-6 r_length=20e-6 m=1
XR5 R_node_out net3 VGND ppolyf_u_1k r_width=2e-6 r_length=20e-6 m=1
.ends

* expanding   symbol:  dac_sub_therm.sym # of pins=3
** sym_path: /home/j542yu/Documents/ece298a-msk-modem/xschem/dac_sub_therm.sym
** sch_path: /home/j542yu/Documents/ece298a-msk-modem/xschem/dac_sub_therm.sch
.subckt dac_sub_therm R_node in VGND
*.ipin in
*.iopin R_node
*.iopin VGND
XR7 in net1 VGND ppolyf_u_1k r_width=2e-6 r_length=20e-6 m=1
XR1 net1 R_node VGND ppolyf_u_1k r_width=2e-6 r_length=20e-6 m=1
.ends

.end
