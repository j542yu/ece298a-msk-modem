** sch_path: /home/j542yu/Documents/ece298a-msk-modem/xschem/dac_seg_5_3.sch
.subckt dac_seg_5_3 B[4] B[3] B[2] B[1] B[0] T[6] T[5] T[4] T[3] T[2] T[1] T[0] DAC_5_3_OUT
*.PININFO B[4:0]:I T[6:0]:I DAC_5_3_OUT:O
x1 net3 net1 B[0] dac_sub_r2r
x2 net4 net3 B[1] dac_sub_r2r
x3 net5 net4 B[2] dac_sub_r2r
x4 net6 net5 B[3] dac_sub_r2r
x5 DAC_5_3_OUT net6 B[4] dac_sub_r2r
* tap: B[4:0] --> B[0]
* tap: B[4:0] --> B[1]
* tap: B[4:0] --> B[2]
* tap: B[4:0] --> B[3]
* tap: B[4:0] --> B[4]
x6 DAC_5_3_OUT T[0] dac_sub_therm
x7 DAC_5_3_OUT T[1] dac_sub_therm
x8 DAC_5_3_OUT T[2] dac_sub_therm
x9 DAC_5_3_OUT T[3] dac_sub_therm
x10 DAC_5_3_OUT T[4] dac_sub_therm
x11 DAC_5_3_OUT T[5] dac_sub_therm
x12 DAC_5_3_OUT T[6] dac_sub_therm
* tap: T[6:0] --> T[0]
* tap: T[6:0] --> T[1]
* tap: T[6:0] --> T[2]
* tap: T[6:0] --> T[3]
* tap: T[6:0] --> T[4]
* tap: T[6:0] --> T[5]
* tap: T[6:0] --> T[6]
XR2 GND net7 GND ppolyf_u_1k r_width=20e-6 r_length=2e-6 m=1
XR3 net7 net1 GND ppolyf_u_1k r_width=20e-6 r_length=2e-6 m=1
XR4 GND net2 GND ppolyf_u_1k r_width=20e-6 r_length=2e-6 m=1
XR5 GND net2 GND ppolyf_u_1k r_width=20e-6 r_length=2e-6 m=1
XR7 GND net2 net8 ppolyf_u_1k r_width=20e-6 r_length=2e-6 m=1
.ends

* expanding   symbol:  dac_sub_r2r.sym # of pins=3
** sym_path: /home/j542yu/Documents/ece298a-msk-modem/xschem/dac_sub_r2r.sym
** sch_path: /home/j542yu/Documents/ece298a-msk-modem/xschem/dac_sub_r2r.sch
.subckt dac_sub_r2r R_node_out R_node_in in
*.PININFO in:I R_node_out:B R_node_in:B
XR7 in net1 GND ppolyf_u_1k r_width=20e-6 r_length=2e-6 m=1
XR1 net1 R_node_in GND ppolyf_u_1k r_width=20e-6 r_length=2e-6 m=1
XR2 net2 R_node_in GND ppolyf_u_1k r_width=20e-6 r_length=2e-6 m=1
XR3 R_node_out net2 GND ppolyf_u_1k r_width=20e-6 r_length=2e-6 m=1
XR4 net3 R_node_in GND ppolyf_u_1k r_width=20e-6 r_length=2e-6 m=1
XR5 R_node_out net3 GND ppolyf_u_1k r_width=20e-6 r_length=2e-6 m=1
.ends

* expanding   symbol:  dac_sub_therm.sym # of pins=2
** sym_path: /home/j542yu/Documents/ece298a-msk-modem/xschem/dac_sub_therm.sym
** sch_path: /home/j542yu/Documents/ece298a-msk-modem/xschem/dac_sub_therm.sch
.subckt dac_sub_therm R_node in
*.PININFO in:I R_node:B
XR7 in net1 GND ppolyf_u_1k r_width=20e-6 r_length=2e-6 m=1
XR1 net1 R_node GND ppolyf_u_1k r_width=20e-6 r_length=2e-6 m=1
.ends

.GLOBAL GND
.end
