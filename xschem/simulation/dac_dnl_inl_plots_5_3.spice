.control

* Run transient simulation
tran 0.2n 5.12e-06 0 0.2n

* Measure DAC output at midpoint of each code interval
meas tran vcode_0 find v(DAC_5_3_OUT) at=1e-08
meas tran vcode_1 find v(DAC_5_3_OUT) at=3e-08
meas tran vcode_2 find v(DAC_5_3_OUT) at=5e-08
meas tran vcode_3 find v(DAC_5_3_OUT) at=7e-08
meas tran vcode_4 find v(DAC_5_3_OUT) at=9e-08
meas tran vcode_5 find v(DAC_5_3_OUT) at=1.1e-07
meas tran vcode_6 find v(DAC_5_3_OUT) at=1.3e-07
meas tran vcode_7 find v(DAC_5_3_OUT) at=1.5e-07
meas tran vcode_8 find v(DAC_5_3_OUT) at=1.7e-07
meas tran vcode_9 find v(DAC_5_3_OUT) at=1.9e-07
meas tran vcode_10 find v(DAC_5_3_OUT) at=2.1e-07
meas tran vcode_11 find v(DAC_5_3_OUT) at=2.3e-07
meas tran vcode_12 find v(DAC_5_3_OUT) at=2.5e-07
meas tran vcode_13 find v(DAC_5_3_OUT) at=2.7e-07
meas tran vcode_14 find v(DAC_5_3_OUT) at=2.9e-07
meas tran vcode_15 find v(DAC_5_3_OUT) at=3.1e-07
meas tran vcode_16 find v(DAC_5_3_OUT) at=3.3e-07
meas tran vcode_17 find v(DAC_5_3_OUT) at=3.5e-07
meas tran vcode_18 find v(DAC_5_3_OUT) at=3.7e-07
meas tran vcode_19 find v(DAC_5_3_OUT) at=3.9e-07
meas tran vcode_20 find v(DAC_5_3_OUT) at=4.1e-07
meas tran vcode_21 find v(DAC_5_3_OUT) at=4.3e-07
meas tran vcode_22 find v(DAC_5_3_OUT) at=4.5e-07
meas tran vcode_23 find v(DAC_5_3_OUT) at=4.7e-07
meas tran vcode_24 find v(DAC_5_3_OUT) at=4.9e-07
meas tran vcode_25 find v(DAC_5_3_OUT) at=5.1e-07
meas tran vcode_26 find v(DAC_5_3_OUT) at=5.3e-07
meas tran vcode_27 find v(DAC_5_3_OUT) at=5.5e-07
meas tran vcode_28 find v(DAC_5_3_OUT) at=5.7e-07
meas tran vcode_29 find v(DAC_5_3_OUT) at=5.9e-07
meas tran vcode_30 find v(DAC_5_3_OUT) at=6.1e-07
meas tran vcode_31 find v(DAC_5_3_OUT) at=6.3e-07
meas tran vcode_32 find v(DAC_5_3_OUT) at=6.5e-07
meas tran vcode_33 find v(DAC_5_3_OUT) at=6.7e-07
meas tran vcode_34 find v(DAC_5_3_OUT) at=6.9e-07
meas tran vcode_35 find v(DAC_5_3_OUT) at=7.1e-07
meas tran vcode_36 find v(DAC_5_3_OUT) at=7.3e-07
meas tran vcode_37 find v(DAC_5_3_OUT) at=7.5e-07
meas tran vcode_38 find v(DAC_5_3_OUT) at=7.7e-07
meas tran vcode_39 find v(DAC_5_3_OUT) at=7.9e-07
meas tran vcode_40 find v(DAC_5_3_OUT) at=8.1e-07
meas tran vcode_41 find v(DAC_5_3_OUT) at=8.3e-07
meas tran vcode_42 find v(DAC_5_3_OUT) at=8.5e-07
meas tran vcode_43 find v(DAC_5_3_OUT) at=8.7e-07
meas tran vcode_44 find v(DAC_5_3_OUT) at=8.9e-07
meas tran vcode_45 find v(DAC_5_3_OUT) at=9.1e-07
meas tran vcode_46 find v(DAC_5_3_OUT) at=9.3e-07
meas tran vcode_47 find v(DAC_5_3_OUT) at=9.5e-07
meas tran vcode_48 find v(DAC_5_3_OUT) at=9.7e-07
meas tran vcode_49 find v(DAC_5_3_OUT) at=9.9e-07
meas tran vcode_50 find v(DAC_5_3_OUT) at=1.01e-06
meas tran vcode_51 find v(DAC_5_3_OUT) at=1.03e-06
meas tran vcode_52 find v(DAC_5_3_OUT) at=1.05e-06
meas tran vcode_53 find v(DAC_5_3_OUT) at=1.07e-06
meas tran vcode_54 find v(DAC_5_3_OUT) at=1.09e-06
meas tran vcode_55 find v(DAC_5_3_OUT) at=1.11e-06
meas tran vcode_56 find v(DAC_5_3_OUT) at=1.13e-06
meas tran vcode_57 find v(DAC_5_3_OUT) at=1.15e-06
meas tran vcode_58 find v(DAC_5_3_OUT) at=1.17e-06
meas tran vcode_59 find v(DAC_5_3_OUT) at=1.19e-06
meas tran vcode_60 find v(DAC_5_3_OUT) at=1.21e-06
meas tran vcode_61 find v(DAC_5_3_OUT) at=1.23e-06
meas tran vcode_62 find v(DAC_5_3_OUT) at=1.25e-06
meas tran vcode_63 find v(DAC_5_3_OUT) at=1.27e-06
meas tran vcode_64 find v(DAC_5_3_OUT) at=1.29e-06
meas tran vcode_65 find v(DAC_5_3_OUT) at=1.31e-06
meas tran vcode_66 find v(DAC_5_3_OUT) at=1.33e-06
meas tran vcode_67 find v(DAC_5_3_OUT) at=1.35e-06
meas tran vcode_68 find v(DAC_5_3_OUT) at=1.37e-06
meas tran vcode_69 find v(DAC_5_3_OUT) at=1.39e-06
meas tran vcode_70 find v(DAC_5_3_OUT) at=1.41e-06
meas tran vcode_71 find v(DAC_5_3_OUT) at=1.43e-06
meas tran vcode_72 find v(DAC_5_3_OUT) at=1.45e-06
meas tran vcode_73 find v(DAC_5_3_OUT) at=1.47e-06
meas tran vcode_74 find v(DAC_5_3_OUT) at=1.49e-06
meas tran vcode_75 find v(DAC_5_3_OUT) at=1.51e-06
meas tran vcode_76 find v(DAC_5_3_OUT) at=1.53e-06
meas tran vcode_77 find v(DAC_5_3_OUT) at=1.55e-06
meas tran vcode_78 find v(DAC_5_3_OUT) at=1.57e-06
meas tran vcode_79 find v(DAC_5_3_OUT) at=1.59e-06
meas tran vcode_80 find v(DAC_5_3_OUT) at=1.61e-06
meas tran vcode_81 find v(DAC_5_3_OUT) at=1.63e-06
meas tran vcode_82 find v(DAC_5_3_OUT) at=1.65e-06
meas tran vcode_83 find v(DAC_5_3_OUT) at=1.67e-06
meas tran vcode_84 find v(DAC_5_3_OUT) at=1.69e-06
meas tran vcode_85 find v(DAC_5_3_OUT) at=1.71e-06
meas tran vcode_86 find v(DAC_5_3_OUT) at=1.73e-06
meas tran vcode_87 find v(DAC_5_3_OUT) at=1.75e-06
meas tran vcode_88 find v(DAC_5_3_OUT) at=1.77e-06
meas tran vcode_89 find v(DAC_5_3_OUT) at=1.79e-06
meas tran vcode_90 find v(DAC_5_3_OUT) at=1.81e-06
meas tran vcode_91 find v(DAC_5_3_OUT) at=1.83e-06
meas tran vcode_92 find v(DAC_5_3_OUT) at=1.85e-06
meas tran vcode_93 find v(DAC_5_3_OUT) at=1.87e-06
meas tran vcode_94 find v(DAC_5_3_OUT) at=1.89e-06
meas tran vcode_95 find v(DAC_5_3_OUT) at=1.91e-06
meas tran vcode_96 find v(DAC_5_3_OUT) at=1.93e-06
meas tran vcode_97 find v(DAC_5_3_OUT) at=1.95e-06
meas tran vcode_98 find v(DAC_5_3_OUT) at=1.97e-06
meas tran vcode_99 find v(DAC_5_3_OUT) at=1.99e-06
meas tran vcode_100 find v(DAC_5_3_OUT) at=2.01e-06
meas tran vcode_101 find v(DAC_5_3_OUT) at=2.03e-06
meas tran vcode_102 find v(DAC_5_3_OUT) at=2.05e-06
meas tran vcode_103 find v(DAC_5_3_OUT) at=2.07e-06
meas tran vcode_104 find v(DAC_5_3_OUT) at=2.09e-06
meas tran vcode_105 find v(DAC_5_3_OUT) at=2.11e-06
meas tran vcode_106 find v(DAC_5_3_OUT) at=2.13e-06
meas tran vcode_107 find v(DAC_5_3_OUT) at=2.15e-06
meas tran vcode_108 find v(DAC_5_3_OUT) at=2.17e-06
meas tran vcode_109 find v(DAC_5_3_OUT) at=2.19e-06
meas tran vcode_110 find v(DAC_5_3_OUT) at=2.21e-06
meas tran vcode_111 find v(DAC_5_3_OUT) at=2.23e-06
meas tran vcode_112 find v(DAC_5_3_OUT) at=2.25e-06
meas tran vcode_113 find v(DAC_5_3_OUT) at=2.27e-06
meas tran vcode_114 find v(DAC_5_3_OUT) at=2.29e-06
meas tran vcode_115 find v(DAC_5_3_OUT) at=2.31e-06
meas tran vcode_116 find v(DAC_5_3_OUT) at=2.33e-06
meas tran vcode_117 find v(DAC_5_3_OUT) at=2.35e-06
meas tran vcode_118 find v(DAC_5_3_OUT) at=2.37e-06
meas tran vcode_119 find v(DAC_5_3_OUT) at=2.39e-06
meas tran vcode_120 find v(DAC_5_3_OUT) at=2.41e-06
meas tran vcode_121 find v(DAC_5_3_OUT) at=2.43e-06
meas tran vcode_122 find v(DAC_5_3_OUT) at=2.45e-06
meas tran vcode_123 find v(DAC_5_3_OUT) at=2.47e-06
meas tran vcode_124 find v(DAC_5_3_OUT) at=2.49e-06
meas tran vcode_125 find v(DAC_5_3_OUT) at=2.51e-06
meas tran vcode_126 find v(DAC_5_3_OUT) at=2.53e-06
meas tran vcode_127 find v(DAC_5_3_OUT) at=2.55e-06
meas tran vcode_128 find v(DAC_5_3_OUT) at=2.57e-06
meas tran vcode_129 find v(DAC_5_3_OUT) at=2.59e-06
meas tran vcode_130 find v(DAC_5_3_OUT) at=2.61e-06
meas tran vcode_131 find v(DAC_5_3_OUT) at=2.63e-06
meas tran vcode_132 find v(DAC_5_3_OUT) at=2.65e-06
meas tran vcode_133 find v(DAC_5_3_OUT) at=2.67e-06
meas tran vcode_134 find v(DAC_5_3_OUT) at=2.69e-06
meas tran vcode_135 find v(DAC_5_3_OUT) at=2.71e-06
meas tran vcode_136 find v(DAC_5_3_OUT) at=2.73e-06
meas tran vcode_137 find v(DAC_5_3_OUT) at=2.75e-06
meas tran vcode_138 find v(DAC_5_3_OUT) at=2.77e-06
meas tran vcode_139 find v(DAC_5_3_OUT) at=2.79e-06
meas tran vcode_140 find v(DAC_5_3_OUT) at=2.81e-06
meas tran vcode_141 find v(DAC_5_3_OUT) at=2.83e-06
meas tran vcode_142 find v(DAC_5_3_OUT) at=2.85e-06
meas tran vcode_143 find v(DAC_5_3_OUT) at=2.87e-06
meas tran vcode_144 find v(DAC_5_3_OUT) at=2.89e-06
meas tran vcode_145 find v(DAC_5_3_OUT) at=2.91e-06
meas tran vcode_146 find v(DAC_5_3_OUT) at=2.93e-06
meas tran vcode_147 find v(DAC_5_3_OUT) at=2.95e-06
meas tran vcode_148 find v(DAC_5_3_OUT) at=2.97e-06
meas tran vcode_149 find v(DAC_5_3_OUT) at=2.99e-06
meas tran vcode_150 find v(DAC_5_3_OUT) at=3.01e-06
meas tran vcode_151 find v(DAC_5_3_OUT) at=3.03e-06
meas tran vcode_152 find v(DAC_5_3_OUT) at=3.05e-06
meas tran vcode_153 find v(DAC_5_3_OUT) at=3.07e-06
meas tran vcode_154 find v(DAC_5_3_OUT) at=3.09e-06
meas tran vcode_155 find v(DAC_5_3_OUT) at=3.11e-06
meas tran vcode_156 find v(DAC_5_3_OUT) at=3.13e-06
meas tran vcode_157 find v(DAC_5_3_OUT) at=3.15e-06
meas tran vcode_158 find v(DAC_5_3_OUT) at=3.17e-06
meas tran vcode_159 find v(DAC_5_3_OUT) at=3.19e-06
meas tran vcode_160 find v(DAC_5_3_OUT) at=3.21e-06
meas tran vcode_161 find v(DAC_5_3_OUT) at=3.23e-06
meas tran vcode_162 find v(DAC_5_3_OUT) at=3.25e-06
meas tran vcode_163 find v(DAC_5_3_OUT) at=3.27e-06
meas tran vcode_164 find v(DAC_5_3_OUT) at=3.29e-06
meas tran vcode_165 find v(DAC_5_3_OUT) at=3.31e-06
meas tran vcode_166 find v(DAC_5_3_OUT) at=3.33e-06
meas tran vcode_167 find v(DAC_5_3_OUT) at=3.35e-06
meas tran vcode_168 find v(DAC_5_3_OUT) at=3.37e-06
meas tran vcode_169 find v(DAC_5_3_OUT) at=3.39e-06
meas tran vcode_170 find v(DAC_5_3_OUT) at=3.41e-06
meas tran vcode_171 find v(DAC_5_3_OUT) at=3.43e-06
meas tran vcode_172 find v(DAC_5_3_OUT) at=3.45e-06
meas tran vcode_173 find v(DAC_5_3_OUT) at=3.47e-06
meas tran vcode_174 find v(DAC_5_3_OUT) at=3.49e-06
meas tran vcode_175 find v(DAC_5_3_OUT) at=3.51e-06
meas tran vcode_176 find v(DAC_5_3_OUT) at=3.53e-06
meas tran vcode_177 find v(DAC_5_3_OUT) at=3.55e-06
meas tran vcode_178 find v(DAC_5_3_OUT) at=3.57e-06
meas tran vcode_179 find v(DAC_5_3_OUT) at=3.59e-06
meas tran vcode_180 find v(DAC_5_3_OUT) at=3.61e-06
meas tran vcode_181 find v(DAC_5_3_OUT) at=3.63e-06
meas tran vcode_182 find v(DAC_5_3_OUT) at=3.65e-06
meas tran vcode_183 find v(DAC_5_3_OUT) at=3.67e-06
meas tran vcode_184 find v(DAC_5_3_OUT) at=3.69e-06
meas tran vcode_185 find v(DAC_5_3_OUT) at=3.71e-06
meas tran vcode_186 find v(DAC_5_3_OUT) at=3.73e-06
meas tran vcode_187 find v(DAC_5_3_OUT) at=3.75e-06
meas tran vcode_188 find v(DAC_5_3_OUT) at=3.77e-06
meas tran vcode_189 find v(DAC_5_3_OUT) at=3.79e-06
meas tran vcode_190 find v(DAC_5_3_OUT) at=3.81e-06
meas tran vcode_191 find v(DAC_5_3_OUT) at=3.83e-06
meas tran vcode_192 find v(DAC_5_3_OUT) at=3.85e-06
meas tran vcode_193 find v(DAC_5_3_OUT) at=3.87e-06
meas tran vcode_194 find v(DAC_5_3_OUT) at=3.89e-06
meas tran vcode_195 find v(DAC_5_3_OUT) at=3.91e-06
meas tran vcode_196 find v(DAC_5_3_OUT) at=3.93e-06
meas tran vcode_197 find v(DAC_5_3_OUT) at=3.95e-06
meas tran vcode_198 find v(DAC_5_3_OUT) at=3.97e-06
meas tran vcode_199 find v(DAC_5_3_OUT) at=3.99e-06
meas tran vcode_200 find v(DAC_5_3_OUT) at=4.01e-06
meas tran vcode_201 find v(DAC_5_3_OUT) at=4.03e-06
meas tran vcode_202 find v(DAC_5_3_OUT) at=4.05e-06
meas tran vcode_203 find v(DAC_5_3_OUT) at=4.07e-06
meas tran vcode_204 find v(DAC_5_3_OUT) at=4.09e-06
meas tran vcode_205 find v(DAC_5_3_OUT) at=4.11e-06
meas tran vcode_206 find v(DAC_5_3_OUT) at=4.13e-06
meas tran vcode_207 find v(DAC_5_3_OUT) at=4.15e-06
meas tran vcode_208 find v(DAC_5_3_OUT) at=4.17e-06
meas tran vcode_209 find v(DAC_5_3_OUT) at=4.19e-06
meas tran vcode_210 find v(DAC_5_3_OUT) at=4.21e-06
meas tran vcode_211 find v(DAC_5_3_OUT) at=4.23e-06
meas tran vcode_212 find v(DAC_5_3_OUT) at=4.25e-06
meas tran vcode_213 find v(DAC_5_3_OUT) at=4.27e-06
meas tran vcode_214 find v(DAC_5_3_OUT) at=4.29e-06
meas tran vcode_215 find v(DAC_5_3_OUT) at=4.31e-06
meas tran vcode_216 find v(DAC_5_3_OUT) at=4.33e-06
meas tran vcode_217 find v(DAC_5_3_OUT) at=4.35e-06
meas tran vcode_218 find v(DAC_5_3_OUT) at=4.37e-06
meas tran vcode_219 find v(DAC_5_3_OUT) at=4.39e-06
meas tran vcode_220 find v(DAC_5_3_OUT) at=4.41e-06
meas tran vcode_221 find v(DAC_5_3_OUT) at=4.43e-06
meas tran vcode_222 find v(DAC_5_3_OUT) at=4.45e-06
meas tran vcode_223 find v(DAC_5_3_OUT) at=4.47e-06
meas tran vcode_224 find v(DAC_5_3_OUT) at=4.49e-06
meas tran vcode_225 find v(DAC_5_3_OUT) at=4.51e-06
meas tran vcode_226 find v(DAC_5_3_OUT) at=4.53e-06
meas tran vcode_227 find v(DAC_5_3_OUT) at=4.55e-06
meas tran vcode_228 find v(DAC_5_3_OUT) at=4.57e-06
meas tran vcode_229 find v(DAC_5_3_OUT) at=4.59e-06
meas tran vcode_230 find v(DAC_5_3_OUT) at=4.61e-06
meas tran vcode_231 find v(DAC_5_3_OUT) at=4.63e-06
meas tran vcode_232 find v(DAC_5_3_OUT) at=4.65e-06
meas tran vcode_233 find v(DAC_5_3_OUT) at=4.67e-06
meas tran vcode_234 find v(DAC_5_3_OUT) at=4.69e-06
meas tran vcode_235 find v(DAC_5_3_OUT) at=4.71e-06
meas tran vcode_236 find v(DAC_5_3_OUT) at=4.73e-06
meas tran vcode_237 find v(DAC_5_3_OUT) at=4.75e-06
meas tran vcode_238 find v(DAC_5_3_OUT) at=4.77e-06
meas tran vcode_239 find v(DAC_5_3_OUT) at=4.79e-06
meas tran vcode_240 find v(DAC_5_3_OUT) at=4.81e-06
meas tran vcode_241 find v(DAC_5_3_OUT) at=4.83e-06
meas tran vcode_242 find v(DAC_5_3_OUT) at=4.85e-06
meas tran vcode_243 find v(DAC_5_3_OUT) at=4.87e-06
meas tran vcode_244 find v(DAC_5_3_OUT) at=4.89e-06
meas tran vcode_245 find v(DAC_5_3_OUT) at=4.91e-06
meas tran vcode_246 find v(DAC_5_3_OUT) at=4.93e-06
meas tran vcode_247 find v(DAC_5_3_OUT) at=4.95e-06
meas tran vcode_248 find v(DAC_5_3_OUT) at=4.97e-06
meas tran vcode_249 find v(DAC_5_3_OUT) at=4.99e-06
meas tran vcode_250 find v(DAC_5_3_OUT) at=5.01e-06
meas tran vcode_251 find v(DAC_5_3_OUT) at=5.03e-06
meas tran vcode_252 find v(DAC_5_3_OUT) at=5.05e-06
meas tran vcode_253 find v(DAC_5_3_OUT) at=5.07e-06
meas tran vcode_254 find v(DAC_5_3_OUT) at=5.09e-06
meas tran vcode_255 find v(DAC_5_3_OUT) at=5.11e-06

* Calculate endpoint-calibrated LSB
let lsb = (vcode_255 - vcode_0)/255

* Create INL and DNL vectors
let inl = vector(256)
let dnl = vector(255)
let code_inl = vector(256)
let code_dnl = vector(255)

let code_inl[0] = 0
let inl[0] = (vcode_0 - vcode_0 - 0*lsb)/lsb
let code_inl[1] = 1
let inl[1] = (vcode_1 - vcode_0 - 1*lsb)/lsb
let code_inl[2] = 2
let inl[2] = (vcode_2 - vcode_0 - 2*lsb)/lsb
let code_inl[3] = 3
let inl[3] = (vcode_3 - vcode_0 - 3*lsb)/lsb
let code_inl[4] = 4
let inl[4] = (vcode_4 - vcode_0 - 4*lsb)/lsb
let code_inl[5] = 5
let inl[5] = (vcode_5 - vcode_0 - 5*lsb)/lsb
let code_inl[6] = 6
let inl[6] = (vcode_6 - vcode_0 - 6*lsb)/lsb
let code_inl[7] = 7
let inl[7] = (vcode_7 - vcode_0 - 7*lsb)/lsb
let code_inl[8] = 8
let inl[8] = (vcode_8 - vcode_0 - 8*lsb)/lsb
let code_inl[9] = 9
let inl[9] = (vcode_9 - vcode_0 - 9*lsb)/lsb
let code_inl[10] = 10
let inl[10] = (vcode_10 - vcode_0 - 10*lsb)/lsb
let code_inl[11] = 11
let inl[11] = (vcode_11 - vcode_0 - 11*lsb)/lsb
let code_inl[12] = 12
let inl[12] = (vcode_12 - vcode_0 - 12*lsb)/lsb
let code_inl[13] = 13
let inl[13] = (vcode_13 - vcode_0 - 13*lsb)/lsb
let code_inl[14] = 14
let inl[14] = (vcode_14 - vcode_0 - 14*lsb)/lsb
let code_inl[15] = 15
let inl[15] = (vcode_15 - vcode_0 - 15*lsb)/lsb
let code_inl[16] = 16
let inl[16] = (vcode_16 - vcode_0 - 16*lsb)/lsb
let code_inl[17] = 17
let inl[17] = (vcode_17 - vcode_0 - 17*lsb)/lsb
let code_inl[18] = 18
let inl[18] = (vcode_18 - vcode_0 - 18*lsb)/lsb
let code_inl[19] = 19
let inl[19] = (vcode_19 - vcode_0 - 19*lsb)/lsb
let code_inl[20] = 20
let inl[20] = (vcode_20 - vcode_0 - 20*lsb)/lsb
let code_inl[21] = 21
let inl[21] = (vcode_21 - vcode_0 - 21*lsb)/lsb
let code_inl[22] = 22
let inl[22] = (vcode_22 - vcode_0 - 22*lsb)/lsb
let code_inl[23] = 23
let inl[23] = (vcode_23 - vcode_0 - 23*lsb)/lsb
let code_inl[24] = 24
let inl[24] = (vcode_24 - vcode_0 - 24*lsb)/lsb
let code_inl[25] = 25
let inl[25] = (vcode_25 - vcode_0 - 25*lsb)/lsb
let code_inl[26] = 26
let inl[26] = (vcode_26 - vcode_0 - 26*lsb)/lsb
let code_inl[27] = 27
let inl[27] = (vcode_27 - vcode_0 - 27*lsb)/lsb
let code_inl[28] = 28
let inl[28] = (vcode_28 - vcode_0 - 28*lsb)/lsb
let code_inl[29] = 29
let inl[29] = (vcode_29 - vcode_0 - 29*lsb)/lsb
let code_inl[30] = 30
let inl[30] = (vcode_30 - vcode_0 - 30*lsb)/lsb
let code_inl[31] = 31
let inl[31] = (vcode_31 - vcode_0 - 31*lsb)/lsb
let code_inl[32] = 32
let inl[32] = (vcode_32 - vcode_0 - 32*lsb)/lsb
let code_inl[33] = 33
let inl[33] = (vcode_33 - vcode_0 - 33*lsb)/lsb
let code_inl[34] = 34
let inl[34] = (vcode_34 - vcode_0 - 34*lsb)/lsb
let code_inl[35] = 35
let inl[35] = (vcode_35 - vcode_0 - 35*lsb)/lsb
let code_inl[36] = 36
let inl[36] = (vcode_36 - vcode_0 - 36*lsb)/lsb
let code_inl[37] = 37
let inl[37] = (vcode_37 - vcode_0 - 37*lsb)/lsb
let code_inl[38] = 38
let inl[38] = (vcode_38 - vcode_0 - 38*lsb)/lsb
let code_inl[39] = 39
let inl[39] = (vcode_39 - vcode_0 - 39*lsb)/lsb
let code_inl[40] = 40
let inl[40] = (vcode_40 - vcode_0 - 40*lsb)/lsb
let code_inl[41] = 41
let inl[41] = (vcode_41 - vcode_0 - 41*lsb)/lsb
let code_inl[42] = 42
let inl[42] = (vcode_42 - vcode_0 - 42*lsb)/lsb
let code_inl[43] = 43
let inl[43] = (vcode_43 - vcode_0 - 43*lsb)/lsb
let code_inl[44] = 44
let inl[44] = (vcode_44 - vcode_0 - 44*lsb)/lsb
let code_inl[45] = 45
let inl[45] = (vcode_45 - vcode_0 - 45*lsb)/lsb
let code_inl[46] = 46
let inl[46] = (vcode_46 - vcode_0 - 46*lsb)/lsb
let code_inl[47] = 47
let inl[47] = (vcode_47 - vcode_0 - 47*lsb)/lsb
let code_inl[48] = 48
let inl[48] = (vcode_48 - vcode_0 - 48*lsb)/lsb
let code_inl[49] = 49
let inl[49] = (vcode_49 - vcode_0 - 49*lsb)/lsb
let code_inl[50] = 50
let inl[50] = (vcode_50 - vcode_0 - 50*lsb)/lsb
let code_inl[51] = 51
let inl[51] = (vcode_51 - vcode_0 - 51*lsb)/lsb
let code_inl[52] = 52
let inl[52] = (vcode_52 - vcode_0 - 52*lsb)/lsb
let code_inl[53] = 53
let inl[53] = (vcode_53 - vcode_0 - 53*lsb)/lsb
let code_inl[54] = 54
let inl[54] = (vcode_54 - vcode_0 - 54*lsb)/lsb
let code_inl[55] = 55
let inl[55] = (vcode_55 - vcode_0 - 55*lsb)/lsb
let code_inl[56] = 56
let inl[56] = (vcode_56 - vcode_0 - 56*lsb)/lsb
let code_inl[57] = 57
let inl[57] = (vcode_57 - vcode_0 - 57*lsb)/lsb
let code_inl[58] = 58
let inl[58] = (vcode_58 - vcode_0 - 58*lsb)/lsb
let code_inl[59] = 59
let inl[59] = (vcode_59 - vcode_0 - 59*lsb)/lsb
let code_inl[60] = 60
let inl[60] = (vcode_60 - vcode_0 - 60*lsb)/lsb
let code_inl[61] = 61
let inl[61] = (vcode_61 - vcode_0 - 61*lsb)/lsb
let code_inl[62] = 62
let inl[62] = (vcode_62 - vcode_0 - 62*lsb)/lsb
let code_inl[63] = 63
let inl[63] = (vcode_63 - vcode_0 - 63*lsb)/lsb
let code_inl[64] = 64
let inl[64] = (vcode_64 - vcode_0 - 64*lsb)/lsb
let code_inl[65] = 65
let inl[65] = (vcode_65 - vcode_0 - 65*lsb)/lsb
let code_inl[66] = 66
let inl[66] = (vcode_66 - vcode_0 - 66*lsb)/lsb
let code_inl[67] = 67
let inl[67] = (vcode_67 - vcode_0 - 67*lsb)/lsb
let code_inl[68] = 68
let inl[68] = (vcode_68 - vcode_0 - 68*lsb)/lsb
let code_inl[69] = 69
let inl[69] = (vcode_69 - vcode_0 - 69*lsb)/lsb
let code_inl[70] = 70
let inl[70] = (vcode_70 - vcode_0 - 70*lsb)/lsb
let code_inl[71] = 71
let inl[71] = (vcode_71 - vcode_0 - 71*lsb)/lsb
let code_inl[72] = 72
let inl[72] = (vcode_72 - vcode_0 - 72*lsb)/lsb
let code_inl[73] = 73
let inl[73] = (vcode_73 - vcode_0 - 73*lsb)/lsb
let code_inl[74] = 74
let inl[74] = (vcode_74 - vcode_0 - 74*lsb)/lsb
let code_inl[75] = 75
let inl[75] = (vcode_75 - vcode_0 - 75*lsb)/lsb
let code_inl[76] = 76
let inl[76] = (vcode_76 - vcode_0 - 76*lsb)/lsb
let code_inl[77] = 77
let inl[77] = (vcode_77 - vcode_0 - 77*lsb)/lsb
let code_inl[78] = 78
let inl[78] = (vcode_78 - vcode_0 - 78*lsb)/lsb
let code_inl[79] = 79
let inl[79] = (vcode_79 - vcode_0 - 79*lsb)/lsb
let code_inl[80] = 80
let inl[80] = (vcode_80 - vcode_0 - 80*lsb)/lsb
let code_inl[81] = 81
let inl[81] = (vcode_81 - vcode_0 - 81*lsb)/lsb
let code_inl[82] = 82
let inl[82] = (vcode_82 - vcode_0 - 82*lsb)/lsb
let code_inl[83] = 83
let inl[83] = (vcode_83 - vcode_0 - 83*lsb)/lsb
let code_inl[84] = 84
let inl[84] = (vcode_84 - vcode_0 - 84*lsb)/lsb
let code_inl[85] = 85
let inl[85] = (vcode_85 - vcode_0 - 85*lsb)/lsb
let code_inl[86] = 86
let inl[86] = (vcode_86 - vcode_0 - 86*lsb)/lsb
let code_inl[87] = 87
let inl[87] = (vcode_87 - vcode_0 - 87*lsb)/lsb
let code_inl[88] = 88
let inl[88] = (vcode_88 - vcode_0 - 88*lsb)/lsb
let code_inl[89] = 89
let inl[89] = (vcode_89 - vcode_0 - 89*lsb)/lsb
let code_inl[90] = 90
let inl[90] = (vcode_90 - vcode_0 - 90*lsb)/lsb
let code_inl[91] = 91
let inl[91] = (vcode_91 - vcode_0 - 91*lsb)/lsb
let code_inl[92] = 92
let inl[92] = (vcode_92 - vcode_0 - 92*lsb)/lsb
let code_inl[93] = 93
let inl[93] = (vcode_93 - vcode_0 - 93*lsb)/lsb
let code_inl[94] = 94
let inl[94] = (vcode_94 - vcode_0 - 94*lsb)/lsb
let code_inl[95] = 95
let inl[95] = (vcode_95 - vcode_0 - 95*lsb)/lsb
let code_inl[96] = 96
let inl[96] = (vcode_96 - vcode_0 - 96*lsb)/lsb
let code_inl[97] = 97
let inl[97] = (vcode_97 - vcode_0 - 97*lsb)/lsb
let code_inl[98] = 98
let inl[98] = (vcode_98 - vcode_0 - 98*lsb)/lsb
let code_inl[99] = 99
let inl[99] = (vcode_99 - vcode_0 - 99*lsb)/lsb
let code_inl[100] = 100
let inl[100] = (vcode_100 - vcode_0 - 100*lsb)/lsb
let code_inl[101] = 101
let inl[101] = (vcode_101 - vcode_0 - 101*lsb)/lsb
let code_inl[102] = 102
let inl[102] = (vcode_102 - vcode_0 - 102*lsb)/lsb
let code_inl[103] = 103
let inl[103] = (vcode_103 - vcode_0 - 103*lsb)/lsb
let code_inl[104] = 104
let inl[104] = (vcode_104 - vcode_0 - 104*lsb)/lsb
let code_inl[105] = 105
let inl[105] = (vcode_105 - vcode_0 - 105*lsb)/lsb
let code_inl[106] = 106
let inl[106] = (vcode_106 - vcode_0 - 106*lsb)/lsb
let code_inl[107] = 107
let inl[107] = (vcode_107 - vcode_0 - 107*lsb)/lsb
let code_inl[108] = 108
let inl[108] = (vcode_108 - vcode_0 - 108*lsb)/lsb
let code_inl[109] = 109
let inl[109] = (vcode_109 - vcode_0 - 109*lsb)/lsb
let code_inl[110] = 110
let inl[110] = (vcode_110 - vcode_0 - 110*lsb)/lsb
let code_inl[111] = 111
let inl[111] = (vcode_111 - vcode_0 - 111*lsb)/lsb
let code_inl[112] = 112
let inl[112] = (vcode_112 - vcode_0 - 112*lsb)/lsb
let code_inl[113] = 113
let inl[113] = (vcode_113 - vcode_0 - 113*lsb)/lsb
let code_inl[114] = 114
let inl[114] = (vcode_114 - vcode_0 - 114*lsb)/lsb
let code_inl[115] = 115
let inl[115] = (vcode_115 - vcode_0 - 115*lsb)/lsb
let code_inl[116] = 116
let inl[116] = (vcode_116 - vcode_0 - 116*lsb)/lsb
let code_inl[117] = 117
let inl[117] = (vcode_117 - vcode_0 - 117*lsb)/lsb
let code_inl[118] = 118
let inl[118] = (vcode_118 - vcode_0 - 118*lsb)/lsb
let code_inl[119] = 119
let inl[119] = (vcode_119 - vcode_0 - 119*lsb)/lsb
let code_inl[120] = 120
let inl[120] = (vcode_120 - vcode_0 - 120*lsb)/lsb
let code_inl[121] = 121
let inl[121] = (vcode_121 - vcode_0 - 121*lsb)/lsb
let code_inl[122] = 122
let inl[122] = (vcode_122 - vcode_0 - 122*lsb)/lsb
let code_inl[123] = 123
let inl[123] = (vcode_123 - vcode_0 - 123*lsb)/lsb
let code_inl[124] = 124
let inl[124] = (vcode_124 - vcode_0 - 124*lsb)/lsb
let code_inl[125] = 125
let inl[125] = (vcode_125 - vcode_0 - 125*lsb)/lsb
let code_inl[126] = 126
let inl[126] = (vcode_126 - vcode_0 - 126*lsb)/lsb
let code_inl[127] = 127
let inl[127] = (vcode_127 - vcode_0 - 127*lsb)/lsb
let code_inl[128] = 128
let inl[128] = (vcode_128 - vcode_0 - 128*lsb)/lsb
let code_inl[129] = 129
let inl[129] = (vcode_129 - vcode_0 - 129*lsb)/lsb
let code_inl[130] = 130
let inl[130] = (vcode_130 - vcode_0 - 130*lsb)/lsb
let code_inl[131] = 131
let inl[131] = (vcode_131 - vcode_0 - 131*lsb)/lsb
let code_inl[132] = 132
let inl[132] = (vcode_132 - vcode_0 - 132*lsb)/lsb
let code_inl[133] = 133
let inl[133] = (vcode_133 - vcode_0 - 133*lsb)/lsb
let code_inl[134] = 134
let inl[134] = (vcode_134 - vcode_0 - 134*lsb)/lsb
let code_inl[135] = 135
let inl[135] = (vcode_135 - vcode_0 - 135*lsb)/lsb
let code_inl[136] = 136
let inl[136] = (vcode_136 - vcode_0 - 136*lsb)/lsb
let code_inl[137] = 137
let inl[137] = (vcode_137 - vcode_0 - 137*lsb)/lsb
let code_inl[138] = 138
let inl[138] = (vcode_138 - vcode_0 - 138*lsb)/lsb
let code_inl[139] = 139
let inl[139] = (vcode_139 - vcode_0 - 139*lsb)/lsb
let code_inl[140] = 140
let inl[140] = (vcode_140 - vcode_0 - 140*lsb)/lsb
let code_inl[141] = 141
let inl[141] = (vcode_141 - vcode_0 - 141*lsb)/lsb
let code_inl[142] = 142
let inl[142] = (vcode_142 - vcode_0 - 142*lsb)/lsb
let code_inl[143] = 143
let inl[143] = (vcode_143 - vcode_0 - 143*lsb)/lsb
let code_inl[144] = 144
let inl[144] = (vcode_144 - vcode_0 - 144*lsb)/lsb
let code_inl[145] = 145
let inl[145] = (vcode_145 - vcode_0 - 145*lsb)/lsb
let code_inl[146] = 146
let inl[146] = (vcode_146 - vcode_0 - 146*lsb)/lsb
let code_inl[147] = 147
let inl[147] = (vcode_147 - vcode_0 - 147*lsb)/lsb
let code_inl[148] = 148
let inl[148] = (vcode_148 - vcode_0 - 148*lsb)/lsb
let code_inl[149] = 149
let inl[149] = (vcode_149 - vcode_0 - 149*lsb)/lsb
let code_inl[150] = 150
let inl[150] = (vcode_150 - vcode_0 - 150*lsb)/lsb
let code_inl[151] = 151
let inl[151] = (vcode_151 - vcode_0 - 151*lsb)/lsb
let code_inl[152] = 152
let inl[152] = (vcode_152 - vcode_0 - 152*lsb)/lsb
let code_inl[153] = 153
let inl[153] = (vcode_153 - vcode_0 - 153*lsb)/lsb
let code_inl[154] = 154
let inl[154] = (vcode_154 - vcode_0 - 154*lsb)/lsb
let code_inl[155] = 155
let inl[155] = (vcode_155 - vcode_0 - 155*lsb)/lsb
let code_inl[156] = 156
let inl[156] = (vcode_156 - vcode_0 - 156*lsb)/lsb
let code_inl[157] = 157
let inl[157] = (vcode_157 - vcode_0 - 157*lsb)/lsb
let code_inl[158] = 158
let inl[158] = (vcode_158 - vcode_0 - 158*lsb)/lsb
let code_inl[159] = 159
let inl[159] = (vcode_159 - vcode_0 - 159*lsb)/lsb
let code_inl[160] = 160
let inl[160] = (vcode_160 - vcode_0 - 160*lsb)/lsb
let code_inl[161] = 161
let inl[161] = (vcode_161 - vcode_0 - 161*lsb)/lsb
let code_inl[162] = 162
let inl[162] = (vcode_162 - vcode_0 - 162*lsb)/lsb
let code_inl[163] = 163
let inl[163] = (vcode_163 - vcode_0 - 163*lsb)/lsb
let code_inl[164] = 164
let inl[164] = (vcode_164 - vcode_0 - 164*lsb)/lsb
let code_inl[165] = 165
let inl[165] = (vcode_165 - vcode_0 - 165*lsb)/lsb
let code_inl[166] = 166
let inl[166] = (vcode_166 - vcode_0 - 166*lsb)/lsb
let code_inl[167] = 167
let inl[167] = (vcode_167 - vcode_0 - 167*lsb)/lsb
let code_inl[168] = 168
let inl[168] = (vcode_168 - vcode_0 - 168*lsb)/lsb
let code_inl[169] = 169
let inl[169] = (vcode_169 - vcode_0 - 169*lsb)/lsb
let code_inl[170] = 170
let inl[170] = (vcode_170 - vcode_0 - 170*lsb)/lsb
let code_inl[171] = 171
let inl[171] = (vcode_171 - vcode_0 - 171*lsb)/lsb
let code_inl[172] = 172
let inl[172] = (vcode_172 - vcode_0 - 172*lsb)/lsb
let code_inl[173] = 173
let inl[173] = (vcode_173 - vcode_0 - 173*lsb)/lsb
let code_inl[174] = 174
let inl[174] = (vcode_174 - vcode_0 - 174*lsb)/lsb
let code_inl[175] = 175
let inl[175] = (vcode_175 - vcode_0 - 175*lsb)/lsb
let code_inl[176] = 176
let inl[176] = (vcode_176 - vcode_0 - 176*lsb)/lsb
let code_inl[177] = 177
let inl[177] = (vcode_177 - vcode_0 - 177*lsb)/lsb
let code_inl[178] = 178
let inl[178] = (vcode_178 - vcode_0 - 178*lsb)/lsb
let code_inl[179] = 179
let inl[179] = (vcode_179 - vcode_0 - 179*lsb)/lsb
let code_inl[180] = 180
let inl[180] = (vcode_180 - vcode_0 - 180*lsb)/lsb
let code_inl[181] = 181
let inl[181] = (vcode_181 - vcode_0 - 181*lsb)/lsb
let code_inl[182] = 182
let inl[182] = (vcode_182 - vcode_0 - 182*lsb)/lsb
let code_inl[183] = 183
let inl[183] = (vcode_183 - vcode_0 - 183*lsb)/lsb
let code_inl[184] = 184
let inl[184] = (vcode_184 - vcode_0 - 184*lsb)/lsb
let code_inl[185] = 185
let inl[185] = (vcode_185 - vcode_0 - 185*lsb)/lsb
let code_inl[186] = 186
let inl[186] = (vcode_186 - vcode_0 - 186*lsb)/lsb
let code_inl[187] = 187
let inl[187] = (vcode_187 - vcode_0 - 187*lsb)/lsb
let code_inl[188] = 188
let inl[188] = (vcode_188 - vcode_0 - 188*lsb)/lsb
let code_inl[189] = 189
let inl[189] = (vcode_189 - vcode_0 - 189*lsb)/lsb
let code_inl[190] = 190
let inl[190] = (vcode_190 - vcode_0 - 190*lsb)/lsb
let code_inl[191] = 191
let inl[191] = (vcode_191 - vcode_0 - 191*lsb)/lsb
let code_inl[192] = 192
let inl[192] = (vcode_192 - vcode_0 - 192*lsb)/lsb
let code_inl[193] = 193
let inl[193] = (vcode_193 - vcode_0 - 193*lsb)/lsb
let code_inl[194] = 194
let inl[194] = (vcode_194 - vcode_0 - 194*lsb)/lsb
let code_inl[195] = 195
let inl[195] = (vcode_195 - vcode_0 - 195*lsb)/lsb
let code_inl[196] = 196
let inl[196] = (vcode_196 - vcode_0 - 196*lsb)/lsb
let code_inl[197] = 197
let inl[197] = (vcode_197 - vcode_0 - 197*lsb)/lsb
let code_inl[198] = 198
let inl[198] = (vcode_198 - vcode_0 - 198*lsb)/lsb
let code_inl[199] = 199
let inl[199] = (vcode_199 - vcode_0 - 199*lsb)/lsb
let code_inl[200] = 200
let inl[200] = (vcode_200 - vcode_0 - 200*lsb)/lsb
let code_inl[201] = 201
let inl[201] = (vcode_201 - vcode_0 - 201*lsb)/lsb
let code_inl[202] = 202
let inl[202] = (vcode_202 - vcode_0 - 202*lsb)/lsb
let code_inl[203] = 203
let inl[203] = (vcode_203 - vcode_0 - 203*lsb)/lsb
let code_inl[204] = 204
let inl[204] = (vcode_204 - vcode_0 - 204*lsb)/lsb
let code_inl[205] = 205
let inl[205] = (vcode_205 - vcode_0 - 205*lsb)/lsb
let code_inl[206] = 206
let inl[206] = (vcode_206 - vcode_0 - 206*lsb)/lsb
let code_inl[207] = 207
let inl[207] = (vcode_207 - vcode_0 - 207*lsb)/lsb
let code_inl[208] = 208
let inl[208] = (vcode_208 - vcode_0 - 208*lsb)/lsb
let code_inl[209] = 209
let inl[209] = (vcode_209 - vcode_0 - 209*lsb)/lsb
let code_inl[210] = 210
let inl[210] = (vcode_210 - vcode_0 - 210*lsb)/lsb
let code_inl[211] = 211
let inl[211] = (vcode_211 - vcode_0 - 211*lsb)/lsb
let code_inl[212] = 212
let inl[212] = (vcode_212 - vcode_0 - 212*lsb)/lsb
let code_inl[213] = 213
let inl[213] = (vcode_213 - vcode_0 - 213*lsb)/lsb
let code_inl[214] = 214
let inl[214] = (vcode_214 - vcode_0 - 214*lsb)/lsb
let code_inl[215] = 215
let inl[215] = (vcode_215 - vcode_0 - 215*lsb)/lsb
let code_inl[216] = 216
let inl[216] = (vcode_216 - vcode_0 - 216*lsb)/lsb
let code_inl[217] = 217
let inl[217] = (vcode_217 - vcode_0 - 217*lsb)/lsb
let code_inl[218] = 218
let inl[218] = (vcode_218 - vcode_0 - 218*lsb)/lsb
let code_inl[219] = 219
let inl[219] = (vcode_219 - vcode_0 - 219*lsb)/lsb
let code_inl[220] = 220
let inl[220] = (vcode_220 - vcode_0 - 220*lsb)/lsb
let code_inl[221] = 221
let inl[221] = (vcode_221 - vcode_0 - 221*lsb)/lsb
let code_inl[222] = 222
let inl[222] = (vcode_222 - vcode_0 - 222*lsb)/lsb
let code_inl[223] = 223
let inl[223] = (vcode_223 - vcode_0 - 223*lsb)/lsb
let code_inl[224] = 224
let inl[224] = (vcode_224 - vcode_0 - 224*lsb)/lsb
let code_inl[225] = 225
let inl[225] = (vcode_225 - vcode_0 - 225*lsb)/lsb
let code_inl[226] = 226
let inl[226] = (vcode_226 - vcode_0 - 226*lsb)/lsb
let code_inl[227] = 227
let inl[227] = (vcode_227 - vcode_0 - 227*lsb)/lsb
let code_inl[228] = 228
let inl[228] = (vcode_228 - vcode_0 - 228*lsb)/lsb
let code_inl[229] = 229
let inl[229] = (vcode_229 - vcode_0 - 229*lsb)/lsb
let code_inl[230] = 230
let inl[230] = (vcode_230 - vcode_0 - 230*lsb)/lsb
let code_inl[231] = 231
let inl[231] = (vcode_231 - vcode_0 - 231*lsb)/lsb
let code_inl[232] = 232
let inl[232] = (vcode_232 - vcode_0 - 232*lsb)/lsb
let code_inl[233] = 233
let inl[233] = (vcode_233 - vcode_0 - 233*lsb)/lsb
let code_inl[234] = 234
let inl[234] = (vcode_234 - vcode_0 - 234*lsb)/lsb
let code_inl[235] = 235
let inl[235] = (vcode_235 - vcode_0 - 235*lsb)/lsb
let code_inl[236] = 236
let inl[236] = (vcode_236 - vcode_0 - 236*lsb)/lsb
let code_inl[237] = 237
let inl[237] = (vcode_237 - vcode_0 - 237*lsb)/lsb
let code_inl[238] = 238
let inl[238] = (vcode_238 - vcode_0 - 238*lsb)/lsb
let code_inl[239] = 239
let inl[239] = (vcode_239 - vcode_0 - 239*lsb)/lsb
let code_inl[240] = 240
let inl[240] = (vcode_240 - vcode_0 - 240*lsb)/lsb
let code_inl[241] = 241
let inl[241] = (vcode_241 - vcode_0 - 241*lsb)/lsb
let code_inl[242] = 242
let inl[242] = (vcode_242 - vcode_0 - 242*lsb)/lsb
let code_inl[243] = 243
let inl[243] = (vcode_243 - vcode_0 - 243*lsb)/lsb
let code_inl[244] = 244
let inl[244] = (vcode_244 - vcode_0 - 244*lsb)/lsb
let code_inl[245] = 245
let inl[245] = (vcode_245 - vcode_0 - 245*lsb)/lsb
let code_inl[246] = 246
let inl[246] = (vcode_246 - vcode_0 - 246*lsb)/lsb
let code_inl[247] = 247
let inl[247] = (vcode_247 - vcode_0 - 247*lsb)/lsb
let code_inl[248] = 248
let inl[248] = (vcode_248 - vcode_0 - 248*lsb)/lsb
let code_inl[249] = 249
let inl[249] = (vcode_249 - vcode_0 - 249*lsb)/lsb
let code_inl[250] = 250
let inl[250] = (vcode_250 - vcode_0 - 250*lsb)/lsb
let code_inl[251] = 251
let inl[251] = (vcode_251 - vcode_0 - 251*lsb)/lsb
let code_inl[252] = 252
let inl[252] = (vcode_252 - vcode_0 - 252*lsb)/lsb
let code_inl[253] = 253
let inl[253] = (vcode_253 - vcode_0 - 253*lsb)/lsb
let code_inl[254] = 254
let inl[254] = (vcode_254 - vcode_0 - 254*lsb)/lsb
let code_inl[255] = 255
let inl[255] = (vcode_255 - vcode_0 - 255*lsb)/lsb
let code_dnl[0] = 0
let dnl[0] = (vcode_1 - vcode_0)/lsb - 1
let code_dnl[1] = 1
let dnl[1] = (vcode_2 - vcode_1)/lsb - 1
let code_dnl[2] = 2
let dnl[2] = (vcode_3 - vcode_2)/lsb - 1
let code_dnl[3] = 3
let dnl[3] = (vcode_4 - vcode_3)/lsb - 1
let code_dnl[4] = 4
let dnl[4] = (vcode_5 - vcode_4)/lsb - 1
let code_dnl[5] = 5
let dnl[5] = (vcode_6 - vcode_5)/lsb - 1
let code_dnl[6] = 6
let dnl[6] = (vcode_7 - vcode_6)/lsb - 1
let code_dnl[7] = 7
let dnl[7] = (vcode_8 - vcode_7)/lsb - 1
let code_dnl[8] = 8
let dnl[8] = (vcode_9 - vcode_8)/lsb - 1
let code_dnl[9] = 9
let dnl[9] = (vcode_10 - vcode_9)/lsb - 1
let code_dnl[10] = 10
let dnl[10] = (vcode_11 - vcode_10)/lsb - 1
let code_dnl[11] = 11
let dnl[11] = (vcode_12 - vcode_11)/lsb - 1
let code_dnl[12] = 12
let dnl[12] = (vcode_13 - vcode_12)/lsb - 1
let code_dnl[13] = 13
let dnl[13] = (vcode_14 - vcode_13)/lsb - 1
let code_dnl[14] = 14
let dnl[14] = (vcode_15 - vcode_14)/lsb - 1
let code_dnl[15] = 15
let dnl[15] = (vcode_16 - vcode_15)/lsb - 1
let code_dnl[16] = 16
let dnl[16] = (vcode_17 - vcode_16)/lsb - 1
let code_dnl[17] = 17
let dnl[17] = (vcode_18 - vcode_17)/lsb - 1
let code_dnl[18] = 18
let dnl[18] = (vcode_19 - vcode_18)/lsb - 1
let code_dnl[19] = 19
let dnl[19] = (vcode_20 - vcode_19)/lsb - 1
let code_dnl[20] = 20
let dnl[20] = (vcode_21 - vcode_20)/lsb - 1
let code_dnl[21] = 21
let dnl[21] = (vcode_22 - vcode_21)/lsb - 1
let code_dnl[22] = 22
let dnl[22] = (vcode_23 - vcode_22)/lsb - 1
let code_dnl[23] = 23
let dnl[23] = (vcode_24 - vcode_23)/lsb - 1
let code_dnl[24] = 24
let dnl[24] = (vcode_25 - vcode_24)/lsb - 1
let code_dnl[25] = 25
let dnl[25] = (vcode_26 - vcode_25)/lsb - 1
let code_dnl[26] = 26
let dnl[26] = (vcode_27 - vcode_26)/lsb - 1
let code_dnl[27] = 27
let dnl[27] = (vcode_28 - vcode_27)/lsb - 1
let code_dnl[28] = 28
let dnl[28] = (vcode_29 - vcode_28)/lsb - 1
let code_dnl[29] = 29
let dnl[29] = (vcode_30 - vcode_29)/lsb - 1
let code_dnl[30] = 30
let dnl[30] = (vcode_31 - vcode_30)/lsb - 1
let code_dnl[31] = 31
let dnl[31] = (vcode_32 - vcode_31)/lsb - 1
let code_dnl[32] = 32
let dnl[32] = (vcode_33 - vcode_32)/lsb - 1
let code_dnl[33] = 33
let dnl[33] = (vcode_34 - vcode_33)/lsb - 1
let code_dnl[34] = 34
let dnl[34] = (vcode_35 - vcode_34)/lsb - 1
let code_dnl[35] = 35
let dnl[35] = (vcode_36 - vcode_35)/lsb - 1
let code_dnl[36] = 36
let dnl[36] = (vcode_37 - vcode_36)/lsb - 1
let code_dnl[37] = 37
let dnl[37] = (vcode_38 - vcode_37)/lsb - 1
let code_dnl[38] = 38
let dnl[38] = (vcode_39 - vcode_38)/lsb - 1
let code_dnl[39] = 39
let dnl[39] = (vcode_40 - vcode_39)/lsb - 1
let code_dnl[40] = 40
let dnl[40] = (vcode_41 - vcode_40)/lsb - 1
let code_dnl[41] = 41
let dnl[41] = (vcode_42 - vcode_41)/lsb - 1
let code_dnl[42] = 42
let dnl[42] = (vcode_43 - vcode_42)/lsb - 1
let code_dnl[43] = 43
let dnl[43] = (vcode_44 - vcode_43)/lsb - 1
let code_dnl[44] = 44
let dnl[44] = (vcode_45 - vcode_44)/lsb - 1
let code_dnl[45] = 45
let dnl[45] = (vcode_46 - vcode_45)/lsb - 1
let code_dnl[46] = 46
let dnl[46] = (vcode_47 - vcode_46)/lsb - 1
let code_dnl[47] = 47
let dnl[47] = (vcode_48 - vcode_47)/lsb - 1
let code_dnl[48] = 48
let dnl[48] = (vcode_49 - vcode_48)/lsb - 1
let code_dnl[49] = 49
let dnl[49] = (vcode_50 - vcode_49)/lsb - 1
let code_dnl[50] = 50
let dnl[50] = (vcode_51 - vcode_50)/lsb - 1
let code_dnl[51] = 51
let dnl[51] = (vcode_52 - vcode_51)/lsb - 1
let code_dnl[52] = 52
let dnl[52] = (vcode_53 - vcode_52)/lsb - 1
let code_dnl[53] = 53
let dnl[53] = (vcode_54 - vcode_53)/lsb - 1
let code_dnl[54] = 54
let dnl[54] = (vcode_55 - vcode_54)/lsb - 1
let code_dnl[55] = 55
let dnl[55] = (vcode_56 - vcode_55)/lsb - 1
let code_dnl[56] = 56
let dnl[56] = (vcode_57 - vcode_56)/lsb - 1
let code_dnl[57] = 57
let dnl[57] = (vcode_58 - vcode_57)/lsb - 1
let code_dnl[58] = 58
let dnl[58] = (vcode_59 - vcode_58)/lsb - 1
let code_dnl[59] = 59
let dnl[59] = (vcode_60 - vcode_59)/lsb - 1
let code_dnl[60] = 60
let dnl[60] = (vcode_61 - vcode_60)/lsb - 1
let code_dnl[61] = 61
let dnl[61] = (vcode_62 - vcode_61)/lsb - 1
let code_dnl[62] = 62
let dnl[62] = (vcode_63 - vcode_62)/lsb - 1
let code_dnl[63] = 63
let dnl[63] = (vcode_64 - vcode_63)/lsb - 1
let code_dnl[64] = 64
let dnl[64] = (vcode_65 - vcode_64)/lsb - 1
let code_dnl[65] = 65
let dnl[65] = (vcode_66 - vcode_65)/lsb - 1
let code_dnl[66] = 66
let dnl[66] = (vcode_67 - vcode_66)/lsb - 1
let code_dnl[67] = 67
let dnl[67] = (vcode_68 - vcode_67)/lsb - 1
let code_dnl[68] = 68
let dnl[68] = (vcode_69 - vcode_68)/lsb - 1
let code_dnl[69] = 69
let dnl[69] = (vcode_70 - vcode_69)/lsb - 1
let code_dnl[70] = 70
let dnl[70] = (vcode_71 - vcode_70)/lsb - 1
let code_dnl[71] = 71
let dnl[71] = (vcode_72 - vcode_71)/lsb - 1
let code_dnl[72] = 72
let dnl[72] = (vcode_73 - vcode_72)/lsb - 1
let code_dnl[73] = 73
let dnl[73] = (vcode_74 - vcode_73)/lsb - 1
let code_dnl[74] = 74
let dnl[74] = (vcode_75 - vcode_74)/lsb - 1
let code_dnl[75] = 75
let dnl[75] = (vcode_76 - vcode_75)/lsb - 1
let code_dnl[76] = 76
let dnl[76] = (vcode_77 - vcode_76)/lsb - 1
let code_dnl[77] = 77
let dnl[77] = (vcode_78 - vcode_77)/lsb - 1
let code_dnl[78] = 78
let dnl[78] = (vcode_79 - vcode_78)/lsb - 1
let code_dnl[79] = 79
let dnl[79] = (vcode_80 - vcode_79)/lsb - 1
let code_dnl[80] = 80
let dnl[80] = (vcode_81 - vcode_80)/lsb - 1
let code_dnl[81] = 81
let dnl[81] = (vcode_82 - vcode_81)/lsb - 1
let code_dnl[82] = 82
let dnl[82] = (vcode_83 - vcode_82)/lsb - 1
let code_dnl[83] = 83
let dnl[83] = (vcode_84 - vcode_83)/lsb - 1
let code_dnl[84] = 84
let dnl[84] = (vcode_85 - vcode_84)/lsb - 1
let code_dnl[85] = 85
let dnl[85] = (vcode_86 - vcode_85)/lsb - 1
let code_dnl[86] = 86
let dnl[86] = (vcode_87 - vcode_86)/lsb - 1
let code_dnl[87] = 87
let dnl[87] = (vcode_88 - vcode_87)/lsb - 1
let code_dnl[88] = 88
let dnl[88] = (vcode_89 - vcode_88)/lsb - 1
let code_dnl[89] = 89
let dnl[89] = (vcode_90 - vcode_89)/lsb - 1
let code_dnl[90] = 90
let dnl[90] = (vcode_91 - vcode_90)/lsb - 1
let code_dnl[91] = 91
let dnl[91] = (vcode_92 - vcode_91)/lsb - 1
let code_dnl[92] = 92
let dnl[92] = (vcode_93 - vcode_92)/lsb - 1
let code_dnl[93] = 93
let dnl[93] = (vcode_94 - vcode_93)/lsb - 1
let code_dnl[94] = 94
let dnl[94] = (vcode_95 - vcode_94)/lsb - 1
let code_dnl[95] = 95
let dnl[95] = (vcode_96 - vcode_95)/lsb - 1
let code_dnl[96] = 96
let dnl[96] = (vcode_97 - vcode_96)/lsb - 1
let code_dnl[97] = 97
let dnl[97] = (vcode_98 - vcode_97)/lsb - 1
let code_dnl[98] = 98
let dnl[98] = (vcode_99 - vcode_98)/lsb - 1
let code_dnl[99] = 99
let dnl[99] = (vcode_100 - vcode_99)/lsb - 1
let code_dnl[100] = 100
let dnl[100] = (vcode_101 - vcode_100)/lsb - 1
let code_dnl[101] = 101
let dnl[101] = (vcode_102 - vcode_101)/lsb - 1
let code_dnl[102] = 102
let dnl[102] = (vcode_103 - vcode_102)/lsb - 1
let code_dnl[103] = 103
let dnl[103] = (vcode_104 - vcode_103)/lsb - 1
let code_dnl[104] = 104
let dnl[104] = (vcode_105 - vcode_104)/lsb - 1
let code_dnl[105] = 105
let dnl[105] = (vcode_106 - vcode_105)/lsb - 1
let code_dnl[106] = 106
let dnl[106] = (vcode_107 - vcode_106)/lsb - 1
let code_dnl[107] = 107
let dnl[107] = (vcode_108 - vcode_107)/lsb - 1
let code_dnl[108] = 108
let dnl[108] = (vcode_109 - vcode_108)/lsb - 1
let code_dnl[109] = 109
let dnl[109] = (vcode_110 - vcode_109)/lsb - 1
let code_dnl[110] = 110
let dnl[110] = (vcode_111 - vcode_110)/lsb - 1
let code_dnl[111] = 111
let dnl[111] = (vcode_112 - vcode_111)/lsb - 1
let code_dnl[112] = 112
let dnl[112] = (vcode_113 - vcode_112)/lsb - 1
let code_dnl[113] = 113
let dnl[113] = (vcode_114 - vcode_113)/lsb - 1
let code_dnl[114] = 114
let dnl[114] = (vcode_115 - vcode_114)/lsb - 1
let code_dnl[115] = 115
let dnl[115] = (vcode_116 - vcode_115)/lsb - 1
let code_dnl[116] = 116
let dnl[116] = (vcode_117 - vcode_116)/lsb - 1
let code_dnl[117] = 117
let dnl[117] = (vcode_118 - vcode_117)/lsb - 1
let code_dnl[118] = 118
let dnl[118] = (vcode_119 - vcode_118)/lsb - 1
let code_dnl[119] = 119
let dnl[119] = (vcode_120 - vcode_119)/lsb - 1
let code_dnl[120] = 120
let dnl[120] = (vcode_121 - vcode_120)/lsb - 1
let code_dnl[121] = 121
let dnl[121] = (vcode_122 - vcode_121)/lsb - 1
let code_dnl[122] = 122
let dnl[122] = (vcode_123 - vcode_122)/lsb - 1
let code_dnl[123] = 123
let dnl[123] = (vcode_124 - vcode_123)/lsb - 1
let code_dnl[124] = 124
let dnl[124] = (vcode_125 - vcode_124)/lsb - 1
let code_dnl[125] = 125
let dnl[125] = (vcode_126 - vcode_125)/lsb - 1
let code_dnl[126] = 126
let dnl[126] = (vcode_127 - vcode_126)/lsb - 1
let code_dnl[127] = 127
let dnl[127] = (vcode_128 - vcode_127)/lsb - 1
let code_dnl[128] = 128
let dnl[128] = (vcode_129 - vcode_128)/lsb - 1
let code_dnl[129] = 129
let dnl[129] = (vcode_130 - vcode_129)/lsb - 1
let code_dnl[130] = 130
let dnl[130] = (vcode_131 - vcode_130)/lsb - 1
let code_dnl[131] = 131
let dnl[131] = (vcode_132 - vcode_131)/lsb - 1
let code_dnl[132] = 132
let dnl[132] = (vcode_133 - vcode_132)/lsb - 1
let code_dnl[133] = 133
let dnl[133] = (vcode_134 - vcode_133)/lsb - 1
let code_dnl[134] = 134
let dnl[134] = (vcode_135 - vcode_134)/lsb - 1
let code_dnl[135] = 135
let dnl[135] = (vcode_136 - vcode_135)/lsb - 1
let code_dnl[136] = 136
let dnl[136] = (vcode_137 - vcode_136)/lsb - 1
let code_dnl[137] = 137
let dnl[137] = (vcode_138 - vcode_137)/lsb - 1
let code_dnl[138] = 138
let dnl[138] = (vcode_139 - vcode_138)/lsb - 1
let code_dnl[139] = 139
let dnl[139] = (vcode_140 - vcode_139)/lsb - 1
let code_dnl[140] = 140
let dnl[140] = (vcode_141 - vcode_140)/lsb - 1
let code_dnl[141] = 141
let dnl[141] = (vcode_142 - vcode_141)/lsb - 1
let code_dnl[142] = 142
let dnl[142] = (vcode_143 - vcode_142)/lsb - 1
let code_dnl[143] = 143
let dnl[143] = (vcode_144 - vcode_143)/lsb - 1
let code_dnl[144] = 144
let dnl[144] = (vcode_145 - vcode_144)/lsb - 1
let code_dnl[145] = 145
let dnl[145] = (vcode_146 - vcode_145)/lsb - 1
let code_dnl[146] = 146
let dnl[146] = (vcode_147 - vcode_146)/lsb - 1
let code_dnl[147] = 147
let dnl[147] = (vcode_148 - vcode_147)/lsb - 1
let code_dnl[148] = 148
let dnl[148] = (vcode_149 - vcode_148)/lsb - 1
let code_dnl[149] = 149
let dnl[149] = (vcode_150 - vcode_149)/lsb - 1
let code_dnl[150] = 150
let dnl[150] = (vcode_151 - vcode_150)/lsb - 1
let code_dnl[151] = 151
let dnl[151] = (vcode_152 - vcode_151)/lsb - 1
let code_dnl[152] = 152
let dnl[152] = (vcode_153 - vcode_152)/lsb - 1
let code_dnl[153] = 153
let dnl[153] = (vcode_154 - vcode_153)/lsb - 1
let code_dnl[154] = 154
let dnl[154] = (vcode_155 - vcode_154)/lsb - 1
let code_dnl[155] = 155
let dnl[155] = (vcode_156 - vcode_155)/lsb - 1
let code_dnl[156] = 156
let dnl[156] = (vcode_157 - vcode_156)/lsb - 1
let code_dnl[157] = 157
let dnl[157] = (vcode_158 - vcode_157)/lsb - 1
let code_dnl[158] = 158
let dnl[158] = (vcode_159 - vcode_158)/lsb - 1
let code_dnl[159] = 159
let dnl[159] = (vcode_160 - vcode_159)/lsb - 1
let code_dnl[160] = 160
let dnl[160] = (vcode_161 - vcode_160)/lsb - 1
let code_dnl[161] = 161
let dnl[161] = (vcode_162 - vcode_161)/lsb - 1
let code_dnl[162] = 162
let dnl[162] = (vcode_163 - vcode_162)/lsb - 1
let code_dnl[163] = 163
let dnl[163] = (vcode_164 - vcode_163)/lsb - 1
let code_dnl[164] = 164
let dnl[164] = (vcode_165 - vcode_164)/lsb - 1
let code_dnl[165] = 165
let dnl[165] = (vcode_166 - vcode_165)/lsb - 1
let code_dnl[166] = 166
let dnl[166] = (vcode_167 - vcode_166)/lsb - 1
let code_dnl[167] = 167
let dnl[167] = (vcode_168 - vcode_167)/lsb - 1
let code_dnl[168] = 168
let dnl[168] = (vcode_169 - vcode_168)/lsb - 1
let code_dnl[169] = 169
let dnl[169] = (vcode_170 - vcode_169)/lsb - 1
let code_dnl[170] = 170
let dnl[170] = (vcode_171 - vcode_170)/lsb - 1
let code_dnl[171] = 171
let dnl[171] = (vcode_172 - vcode_171)/lsb - 1
let code_dnl[172] = 172
let dnl[172] = (vcode_173 - vcode_172)/lsb - 1
let code_dnl[173] = 173
let dnl[173] = (vcode_174 - vcode_173)/lsb - 1
let code_dnl[174] = 174
let dnl[174] = (vcode_175 - vcode_174)/lsb - 1
let code_dnl[175] = 175
let dnl[175] = (vcode_176 - vcode_175)/lsb - 1
let code_dnl[176] = 176
let dnl[176] = (vcode_177 - vcode_176)/lsb - 1
let code_dnl[177] = 177
let dnl[177] = (vcode_178 - vcode_177)/lsb - 1
let code_dnl[178] = 178
let dnl[178] = (vcode_179 - vcode_178)/lsb - 1
let code_dnl[179] = 179
let dnl[179] = (vcode_180 - vcode_179)/lsb - 1
let code_dnl[180] = 180
let dnl[180] = (vcode_181 - vcode_180)/lsb - 1
let code_dnl[181] = 181
let dnl[181] = (vcode_182 - vcode_181)/lsb - 1
let code_dnl[182] = 182
let dnl[182] = (vcode_183 - vcode_182)/lsb - 1
let code_dnl[183] = 183
let dnl[183] = (vcode_184 - vcode_183)/lsb - 1
let code_dnl[184] = 184
let dnl[184] = (vcode_185 - vcode_184)/lsb - 1
let code_dnl[185] = 185
let dnl[185] = (vcode_186 - vcode_185)/lsb - 1
let code_dnl[186] = 186
let dnl[186] = (vcode_187 - vcode_186)/lsb - 1
let code_dnl[187] = 187
let dnl[187] = (vcode_188 - vcode_187)/lsb - 1
let code_dnl[188] = 188
let dnl[188] = (vcode_189 - vcode_188)/lsb - 1
let code_dnl[189] = 189
let dnl[189] = (vcode_190 - vcode_189)/lsb - 1
let code_dnl[190] = 190
let dnl[190] = (vcode_191 - vcode_190)/lsb - 1
let code_dnl[191] = 191
let dnl[191] = (vcode_192 - vcode_191)/lsb - 1
let code_dnl[192] = 192
let dnl[192] = (vcode_193 - vcode_192)/lsb - 1
let code_dnl[193] = 193
let dnl[193] = (vcode_194 - vcode_193)/lsb - 1
let code_dnl[194] = 194
let dnl[194] = (vcode_195 - vcode_194)/lsb - 1
let code_dnl[195] = 195
let dnl[195] = (vcode_196 - vcode_195)/lsb - 1
let code_dnl[196] = 196
let dnl[196] = (vcode_197 - vcode_196)/lsb - 1
let code_dnl[197] = 197
let dnl[197] = (vcode_198 - vcode_197)/lsb - 1
let code_dnl[198] = 198
let dnl[198] = (vcode_199 - vcode_198)/lsb - 1
let code_dnl[199] = 199
let dnl[199] = (vcode_200 - vcode_199)/lsb - 1
let code_dnl[200] = 200
let dnl[200] = (vcode_201 - vcode_200)/lsb - 1
let code_dnl[201] = 201
let dnl[201] = (vcode_202 - vcode_201)/lsb - 1
let code_dnl[202] = 202
let dnl[202] = (vcode_203 - vcode_202)/lsb - 1
let code_dnl[203] = 203
let dnl[203] = (vcode_204 - vcode_203)/lsb - 1
let code_dnl[204] = 204
let dnl[204] = (vcode_205 - vcode_204)/lsb - 1
let code_dnl[205] = 205
let dnl[205] = (vcode_206 - vcode_205)/lsb - 1
let code_dnl[206] = 206
let dnl[206] = (vcode_207 - vcode_206)/lsb - 1
let code_dnl[207] = 207
let dnl[207] = (vcode_208 - vcode_207)/lsb - 1
let code_dnl[208] = 208
let dnl[208] = (vcode_209 - vcode_208)/lsb - 1
let code_dnl[209] = 209
let dnl[209] = (vcode_210 - vcode_209)/lsb - 1
let code_dnl[210] = 210
let dnl[210] = (vcode_211 - vcode_210)/lsb - 1
let code_dnl[211] = 211
let dnl[211] = (vcode_212 - vcode_211)/lsb - 1
let code_dnl[212] = 212
let dnl[212] = (vcode_213 - vcode_212)/lsb - 1
let code_dnl[213] = 213
let dnl[213] = (vcode_214 - vcode_213)/lsb - 1
let code_dnl[214] = 214
let dnl[214] = (vcode_215 - vcode_214)/lsb - 1
let code_dnl[215] = 215
let dnl[215] = (vcode_216 - vcode_215)/lsb - 1
let code_dnl[216] = 216
let dnl[216] = (vcode_217 - vcode_216)/lsb - 1
let code_dnl[217] = 217
let dnl[217] = (vcode_218 - vcode_217)/lsb - 1
let code_dnl[218] = 218
let dnl[218] = (vcode_219 - vcode_218)/lsb - 1
let code_dnl[219] = 219
let dnl[219] = (vcode_220 - vcode_219)/lsb - 1
let code_dnl[220] = 220
let dnl[220] = (vcode_221 - vcode_220)/lsb - 1
let code_dnl[221] = 221
let dnl[221] = (vcode_222 - vcode_221)/lsb - 1
let code_dnl[222] = 222
let dnl[222] = (vcode_223 - vcode_222)/lsb - 1
let code_dnl[223] = 223
let dnl[223] = (vcode_224 - vcode_223)/lsb - 1
let code_dnl[224] = 224
let dnl[224] = (vcode_225 - vcode_224)/lsb - 1
let code_dnl[225] = 225
let dnl[225] = (vcode_226 - vcode_225)/lsb - 1
let code_dnl[226] = 226
let dnl[226] = (vcode_227 - vcode_226)/lsb - 1
let code_dnl[227] = 227
let dnl[227] = (vcode_228 - vcode_227)/lsb - 1
let code_dnl[228] = 228
let dnl[228] = (vcode_229 - vcode_228)/lsb - 1
let code_dnl[229] = 229
let dnl[229] = (vcode_230 - vcode_229)/lsb - 1
let code_dnl[230] = 230
let dnl[230] = (vcode_231 - vcode_230)/lsb - 1
let code_dnl[231] = 231
let dnl[231] = (vcode_232 - vcode_231)/lsb - 1
let code_dnl[232] = 232
let dnl[232] = (vcode_233 - vcode_232)/lsb - 1
let code_dnl[233] = 233
let dnl[233] = (vcode_234 - vcode_233)/lsb - 1
let code_dnl[234] = 234
let dnl[234] = (vcode_235 - vcode_234)/lsb - 1
let code_dnl[235] = 235
let dnl[235] = (vcode_236 - vcode_235)/lsb - 1
let code_dnl[236] = 236
let dnl[236] = (vcode_237 - vcode_236)/lsb - 1
let code_dnl[237] = 237
let dnl[237] = (vcode_238 - vcode_237)/lsb - 1
let code_dnl[238] = 238
let dnl[238] = (vcode_239 - vcode_238)/lsb - 1
let code_dnl[239] = 239
let dnl[239] = (vcode_240 - vcode_239)/lsb - 1
let code_dnl[240] = 240
let dnl[240] = (vcode_241 - vcode_240)/lsb - 1
let code_dnl[241] = 241
let dnl[241] = (vcode_242 - vcode_241)/lsb - 1
let code_dnl[242] = 242
let dnl[242] = (vcode_243 - vcode_242)/lsb - 1
let code_dnl[243] = 243
let dnl[243] = (vcode_244 - vcode_243)/lsb - 1
let code_dnl[244] = 244
let dnl[244] = (vcode_245 - vcode_244)/lsb - 1
let code_dnl[245] = 245
let dnl[245] = (vcode_246 - vcode_245)/lsb - 1
let code_dnl[246] = 246
let dnl[246] = (vcode_247 - vcode_246)/lsb - 1
let code_dnl[247] = 247
let dnl[247] = (vcode_248 - vcode_247)/lsb - 1
let code_dnl[248] = 248
let dnl[248] = (vcode_249 - vcode_248)/lsb - 1
let code_dnl[249] = 249
let dnl[249] = (vcode_250 - vcode_249)/lsb - 1
let code_dnl[250] = 250
let dnl[250] = (vcode_251 - vcode_250)/lsb - 1
let code_dnl[251] = 251
let dnl[251] = (vcode_252 - vcode_251)/lsb - 1
let code_dnl[252] = 252
let dnl[252] = (vcode_253 - vcode_252)/lsb - 1
let code_dnl[253] = 253
let dnl[253] = (vcode_254 - vcode_253)/lsb - 1
let code_dnl[254] = 254
let dnl[254] = (vcode_255 - vcode_254)/lsb - 1

* Plot DNL
plot dnl vs code_dnl

* Plot INL
plot inl vs code_inl

.endc
