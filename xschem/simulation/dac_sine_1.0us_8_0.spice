* Automatically generated DAC stimulus: sine
* DAC bits: 8
* Number of code intervals: 256
* Dwell: 1e-06 s
* Edge duration: 1e-09 s
* Simulation duration: 0.000256 s

V19 B_R[0] GND PWL(0 0 2.999e-06 0 3e-06 3.3 3.999e-06 3.3 4e-06 0 1.1999e-05 0 1.2e-05 3.3 1.2999e-05 3.3 1.3e-05 0 1.3999e-05 0 1.4e-05 3.3 1.4999e-05 3.3 1.5e-05 0 1.5999e-05 0 1.6e-05 3.3 1.6999e-05 3.3 1.7e-05 0 1.7999e-05 0 1.8e-05 3.3 1.8999e-05 3.3 1.9e-05 0 1.9999e-05 0 2e-05 3.3 2.0999e-05 3.3 2.1e-05 0 2.8999e-05 0 2.9e-05 3.3 2.9999e-05 3.3 3e-05 0 3.2999e-05 0 3.3e-05 3.3 3.4999e-05 3.3 3.5e-05 0 3.5999e-05 0 3.6e-05 3.3 4.3999e-05 3.3 4.4e-05 0 4.4999e-05 0 4.5e-05 3.3 4.5999e-05 3.3 4.6e-05 0 4.6999e-05 0 4.7e-05 3.3 4.7999e-05 3.3 4.8e-05 0 4.8999e-05 0 4.9e-05 3.3 4.9999e-05 3.3 5e-05 0 5.0999e-05 0 5.1e-05 3.3 5.1999e-05 3.3 5.2e-05 0 5.2999e-05 0 5.3e-05 3.3 6.0999e-05 3.3 6.1e-05 0 6.1999e-05 0 6.2e-05 3.3 6.4999e-05 3.3 6.5e-05 0 6.6999e-05 0 6.7e-05 3.3 6.7999e-05 3.3 6.8e-05 0 7.5999e-05 0 7.6e-05 3.3 7.6999e-05 3.3 7.7e-05 0 7.7999e-05 0 7.8e-05 3.3 7.8999e-05 3.3 7.9e-05 0 7.9999e-05 0 8e-05 3.3 8.0999e-05 3.3 8.1e-05 0 8.1999e-05 0 8.2e-05 3.3 8.2999e-05 3.3 8.3e-05 0 8.3999e-05 0 8.4e-05 3.3 8.4999e-05 3.3 8.5e-05 0 9.2999e-05 0 9.3e-05 3.3 9.3999e-05 3.3 9.4e-05 0 9.6999e-05 0 9.7e-05 3.3 9.8999e-05 3.3 9.9e-05 0 9.9999e-05 0 0.0001 3.3 0.000107999 3.3 0.000108 0 0.000108999 0 0.000109 3.3 0.000109999 3.3 0.00011 0 0.000110999 0 0.000111 3.3 0.000111999 3.3 0.000112 0 0.000112999 0 0.000113 3.3 0.000113999 3.3 0.000114 0 0.000114999 0 0.000115 3.3 0.000115999 3.3 0.000116 0 0.000116999 0 0.000117 3.3 0.000124999 3.3 0.000125 0 0.000125999 0 0.000126 3.3 0.000128999 3.3 0.000129 0 0.000130999 0 0.000131 3.3 0.000131999 3.3 0.000132 0 0.000139999 0 0.00014 3.3 0.000140999 3.3 0.000141 0 0.000141999 0 0.000142 3.3 0.000142999 3.3 0.000143 0 0.000143999 0 0.000144 3.3 0.000144999 3.3 0.000145 0 0.000145999 0 0.000146 3.3 0.000146999 3.3 0.000147 0 0.000147999 0 0.000148 3.3 0.000148999 3.3 0.000149 0 0.000156999 0 0.000157 3.3 0.000157999 3.3 0.000158 0 0.000160999 0 0.000161 3.3 0.000162999 3.3 0.000163 0 0.000163999 0 0.000164 3.3 0.000171999 3.3 0.000172 0 0.000172999 0 0.000173 3.3 0.000173999 3.3 0.000174 0 0.000174999 0 0.000175 3.3 0.000175999 3.3 0.000176 0 0.000176999 0 0.000177 3.3 0.000177999 3.3 0.000178 0 0.000178999 0 0.000179 3.3 0.000179999 3.3 0.00018 0 0.000180999 0 0.000181 3.3 0.000188999 3.3 0.000189 0 0.000189999 0 0.00019 3.3 0.000192999 3.3 0.000193 0 0.000194999 0 0.000195 3.3 0.000195999 3.3 0.000196 0 0.000203999 0 0.000204 3.3 0.000204999 3.3 0.000205 0 0.000205999 0 0.000206 3.3 0.000206999 3.3 0.000207 0 0.000207999 0 0.000208 3.3 0.000208999 3.3 0.000209 0 0.000209999 0 0.00021 3.3 0.000210999 3.3 0.000211 0 0.000211999 0 0.000212 3.3 0.000212999 3.3 0.000213 0 0.000220999 0 0.000221 3.3 0.000221999 3.3 0.000222 0 0.000224999 0 0.000225 3.3 0.000226999 3.3 0.000227 0 0.000227999 0 0.000228 3.3 0.000235999 3.3 0.000236 0 0.000236999 0 0.000237 3.3 0.000237999 3.3 0.000238 0 0.000238999 0 0.000239 3.3 0.000239999 3.3 0.00024 0 0.000240999 0 0.000241 3.3 0.000241999 3.3 0.000242 0 0.000242999 0 0.000243 3.3 0.000243999 3.3 0.000244 0 0.000244999 0 0.000245 3.3 0.000252999 3.3 0.000253 0 0.000253999 0 0.000254 3.3 0.000256 3.3)
V20 B_R[1] GND PWL(0 0 5.999e-06 0 6e-06 3.3 6.999e-06 3.3 7e-06 0 7.999e-06 0 8e-06 3.3 1.0999e-05 3.3 1.1e-05 0 1.2999e-05 0 1.3e-05 3.3 1.3999e-05 3.3 1.4e-05 0 1.4999e-05 0 1.5e-05 3.3 1.7999e-05 3.3 1.8e-05 0 1.8999e-05 0 1.9e-05 3.3 1.9999e-05 3.3 2e-05 0 2.1999e-05 0 2.2e-05 3.3 2.4999e-05 3.3 2.5e-05 0 2.5999e-05 0 2.6e-05 3.3 2.6999e-05 3.3 2.7e-05 0 3.2999e-05 0 3.3e-05 3.3 3.7999e-05 3.3 3.8e-05 0 3.8999e-05 0 3.9e-05 3.3 3.9999e-05 3.3 4e-05 0 4.2999e-05 0 4.3e-05 3.3 4.4999e-05 3.3 4.5e-05 0 4.5999e-05 0 4.6e-05 3.3 4.6999e-05 3.3 4.7e-05 0 4.9999e-05 0 5e-05 3.3 5.0999e-05 3.3 5.1e-05 0 5.1999e-05 0 5.2e-05 3.3 5.3999e-05 3.3 5.4e-05 0 5.6999e-05 0 5.7e-05 3.3 5.7999e-05 3.3 5.8e-05 0 5.8999e-05 0 5.9e-05 3.3 6.4999e-05 3.3 6.5e-05 0 6.9999e-05 0 7e-05 3.3 7.0999e-05 3.3 7.1e-05 0 7.1999e-05 0 7.2e-05 3.3 7.4999e-05 3.3 7.5e-05 0 7.6999e-05 0 7.7e-05 3.3 7.7999e-05 3.3 7.8e-05 0 7.8999e-05 0 7.9e-05 3.3 8.1999e-05 3.3 8.2e-05 0 8.2999e-05 0 8.3e-05 3.3 8.3999e-05 3.3 8.4e-05 0 8.5999e-05 0 8.6e-05 3.3 8.8999e-05 3.3 8.9e-05 0 8.9999e-05 0 9e-05 3.3 9.0999e-05 3.3 9.1e-05 0 9.6999e-05 0 9.7e-05 3.3 0.000101999 3.3 0.000102 0 0.000102999 0 0.000103 3.3 0.000103999 3.3 0.000104 0 0.000106999 0 0.000107 3.3 0.000108999 3.3 0.000109 0 0.000109999 0 0.00011 3.3 0.000110999 3.3 0.000111 0 0.000113999 0 0.000114 3.3 0.000114999 3.3 0.000115 0 0.000115999 0 0.000116 3.3 0.000117999 3.3 0.000118 0 0.000120999 0 0.000121 3.3 0.000121999 3.3 0.000122 0 0.000122999 0 0.000123 3.3 0.000128999 3.3 0.000129 0 0.000133999 0 0.000134 3.3 0.000134999 3.3 0.000135 0 0.000135999 0 0.000136 3.3 0.000138999 3.3 0.000139 0 0.000140999 0 0.000141 3.3 0.000141999 3.3 0.000142 0 0.000142999 0 0.000143 3.3 0.000145999 3.3 0.000146 0 0.000146999 0 0.000147 3.3 0.000147999 3.3 0.000148 0 0.000149999 0 0.00015 3.3 0.000152999 3.3 0.000153 0 0.000153999 0 0.000154 3.3 0.000154999 3.3 0.000155 0 0.000160999 0 0.000161 3.3 0.000165999 3.3 0.000166 0 0.000166999 0 0.000167 3.3 0.000167999 3.3 0.000168 0 0.000170999 0 0.000171 3.3 0.000172999 3.3 0.000173 0 0.000173999 0 0.000174 3.3 0.000174999 3.3 0.000175 0 0.000177999 0 0.000178 3.3 0.000178999 3.3 0.000179 0 0.000179999 0 0.00018 3.3 0.000181999 3.3 0.000182 0 0.000184999 0 0.000185 3.3 0.000185999 3.3 0.000186 0 0.000186999 0 0.000187 3.3 0.000192999 3.3 0.000193 0 0.000197999 0 0.000198 3.3 0.000198999 3.3 0.000199 0 0.000199999 0 0.0002 3.3 0.000202999 3.3 0.000203 0 0.000204999 0 0.000205 3.3 0.000205999 3.3 0.000206 0 0.000206999 0 0.000207 3.3 0.000209999 3.3 0.00021 0 0.000210999 0 0.000211 3.3 0.000211999 3.3 0.000212 0 0.000213999 0 0.000214 3.3 0.000216999 3.3 0.000217 0 0.000217999 0 0.000218 3.3 0.000218999 3.3 0.000219 0 0.000224999 0 0.000225 3.3 0.000229999 3.3 0.00023 0 0.000230999 0 0.000231 3.3 0.000231999 3.3 0.000232 0 0.000234999 0 0.000235 3.3 0.000236999 3.3 0.000237 0 0.000237999 0 0.000238 3.3 0.000238999 3.3 0.000239 0 0.000241999 0 0.000242 3.3 0.000242999 3.3 0.000243 0 0.000243999 0 0.000244 3.3 0.000245999 3.3 0.000246 0 0.000248999 0 0.000249 3.3 0.000249999 3.3 0.00025 0 0.000250999 0 0.000251 3.3 0.000256 3.3)
V13 B_R[2] GND PWL(0 0 9.99e-07 0 1e-06 3.3 1.999e-06 3.3 2e-06 0 2.999e-06 0 3e-06 3.3 3.999e-06 3.3 4e-06 0 4.999e-06 0 5e-06 3.3 6.999e-06 3.3 7e-06 0 1.1999e-05 0 1.2e-05 3.3 1.2999e-05 3.3 1.3e-05 0 1.3999e-05 0 1.4e-05 3.3 1.8999e-05 3.3 1.9e-05 0 1.9999e-05 0 2e-05 3.3 2.0999e-05 3.3 2.1e-05 0 2.5999e-05 0 2.6e-05 3.3 2.7999e-05 3.3 2.8e-05 0 2.8999e-05 0 2.9e-05 3.3 2.9999e-05 3.3 3e-05 0 3.0999e-05 0 3.1e-05 3.3 3.1999e-05 3.3 3.2e-05 0 3.3999e-05 0 3.4e-05 3.3 3.4999e-05 3.3 3.5e-05 0 3.5999e-05 0 3.6e-05 3.3 3.6999e-05 3.3 3.7e-05 0 3.8999e-05 0 3.9e-05 3.3 4.3999e-05 3.3 4.4e-05 0 4.4999e-05 0 4.5e-05 3.3 4.5999e-05 3.3 4.6e-05 0 5.0999e-05 0 5.1e-05 3.3 5.1999e-05 3.3 5.2e-05 0 5.2999e-05 0 5.3e-05 3.3 5.7999e-05 3.3 5.8e-05 0 5.9999e-05 0 6e-05 3.3 6.0999e-05 3.3 6.1e-05 0 6.1999e-05 0 6.2e-05 3.3 6.2999e-05 3.3 6.3e-05 0 6.3999e-05 0 6.4e-05 3.3 6.5999e-05 3.3 6.6e-05 0 6.6999e-05 0 6.7e-05 3.3 6.7999e-05 3.3 6.8e-05 0 6.8999e-05 0 6.9e-05 3.3 7.0999e-05 3.3 7.1e-05 0 7.5999e-05 0 7.6e-05 3.3 7.6999e-05 3.3 7.7e-05 0 7.7999e-05 0 7.8e-05 3.3 8.2999e-05 3.3 8.3e-05 0 8.3999e-05 0 8.4e-05 3.3 8.4999e-05 3.3 8.5e-05 0 8.9999e-05 0 9e-05 3.3 9.1999e-05 3.3 9.2e-05 0 9.2999e-05 0 9.3e-05 3.3 9.3999e-05 3.3 9.4e-05 0 9.4999e-05 0 9.5e-05 3.3 9.5999e-05 3.3 9.6e-05 0 9.7999e-05 0 9.8e-05 3.3 9.8999e-05 3.3 9.9e-05 0 9.9999e-05 0 0.0001 3.3 0.000100999 3.3 0.000101 0 0.000102999 0 0.000103 3.3 0.000107999 3.3 0.000108 0 0.000108999 0 0.000109 3.3 0.000109999 3.3 0.00011 0 0.000114999 0 0.000115 3.3 0.000115999 3.3 0.000116 0 0.000116999 0 0.000117 3.3 0.000121999 3.3 0.000122 0 0.000123999 0 0.000124 3.3 0.000124999 3.3 0.000125 0 0.000125999 0 0.000126 3.3 0.000126999 3.3 0.000127 0 0.000127999 0 0.000128 3.3 0.000129999 3.3 0.00013 0 0.000130999 0 0.000131 3.3 0.000131999 3.3 0.000132 0 0.000132999 0 0.000133 3.3 0.000134999 3.3 0.000135 0 0.000139999 0 0.00014 3.3 0.000140999 3.3 0.000141 0 0.000141999 0 0.000142 3.3 0.000146999 3.3 0.000147 0 0.000147999 0 0.000148 3.3 0.000148999 3.3 0.000149 0 0.000153999 0 0.000154 3.3 0.000155999 3.3 0.000156 0 0.000156999 0 0.000157 3.3 0.000157999 3.3 0.000158 0 0.000158999 0 0.000159 3.3 0.000159999 3.3 0.00016 0 0.000161999 0 0.000162 3.3 0.000162999 3.3 0.000163 0 0.000163999 0 0.000164 3.3 0.000164999 3.3 0.000165 0 0.000166999 0 0.000167 3.3 0.000171999 3.3 0.000172 0 0.000172999 0 0.000173 3.3 0.000173999 3.3 0.000174 0 0.000178999 0 0.000179 3.3 0.000179999 3.3 0.00018 0 0.000180999 0 0.000181 3.3 0.000185999 3.3 0.000186 0 0.000187999 0 0.000188 3.3 0.000188999 3.3 0.000189 0 0.000189999 0 0.00019 3.3 0.000190999 3.3 0.000191 0 0.000191999 0 0.000192 3.3 0.000193999 3.3 0.000194 0 0.000194999 0 0.000195 3.3 0.000195999 3.3 0.000196 0 0.000196999 0 0.000197 3.3 0.000198999 3.3 0.000199 0 0.000203999 0 0.000204 3.3 0.000204999 3.3 0.000205 0 0.000205999 0 0.000206 3.3 0.000210999 3.3 0.000211 0 0.000211999 0 0.000212 3.3 0.000212999 3.3 0.000213 0 0.000217999 0 0.000218 3.3 0.000219999 3.3 0.00022 0 0.000220999 0 0.000221 3.3 0.000221999 3.3 0.000222 0 0.000222999 0 0.000223 3.3 0.000223999 3.3 0.000224 0 0.000225999 0 0.000226 3.3 0.000226999 3.3 0.000227 0 0.000227999 0 0.000228 3.3 0.000228999 3.3 0.000229 0 0.000230999 0 0.000231 3.3 0.000235999 3.3 0.000236 0 0.000236999 0 0.000237 3.3 0.000237999 3.3 0.000238 0 0.000242999 0 0.000243 3.3 0.000243999 3.3 0.000244 0 0.000244999 0 0.000245 3.3 0.000249999 3.3 0.00025 0 0.000251999 0 0.000252 3.3 0.000252999 3.3 0.000253 0 0.000253999 0 0.000254 3.3 0.000254999 3.3 0.000255 0 0.000256 0)
V14 B_R[3] GND PWL(0 0 9.99e-07 0 1e-06 3.3 2.999e-06 3.3 3e-06 0 4.999e-06 0 5e-06 3.3 5.999e-06 3.3 6e-06 0 7.999e-06 0 8e-06 3.3 8.999e-06 3.3 9e-06 0 9.999e-06 0 1e-05 3.3 1.0999e-05 3.3 1.1e-05 0 1.2999e-05 0 1.3e-05 3.3 1.9999e-05 3.3 2e-05 0 2.1999e-05 0 2.2e-05 3.3 2.2999e-05 3.3 2.3e-05 0 2.3999e-05 0 2.4e-05 3.3 2.4999e-05 3.3 2.5e-05 0 2.6999e-05 0 2.7e-05 3.3 2.7999e-05 3.3 2.8e-05 0 2.9999e-05 0 3e-05 3.3 3.1999e-05 3.3 3.2e-05 0 3.4999e-05 0 3.5e-05 3.3 3.6999e-05 3.3 3.7e-05 0 3.7999e-05 0 3.8e-05 3.3 3.9999e-05 3.3 4e-05 0 4.0999e-05 0 4.1e-05 3.3 4.1999e-05 3.3 4.2e-05 0 4.2999e-05 0 4.3e-05 3.3 4.4999e-05 3.3 4.5e-05 0 5.1999e-05 0 5.2e-05 3.3 5.3999e-05 3.3 5.4e-05 0 5.4999e-05 0 5.5e-05 3.3 5.5999e-05 3.3 5.6e-05 0 5.6999e-05 0 5.7e-05 3.3 5.8999e-05 3.3 5.9e-05 0 5.9999e-05 0 6e-05 3.3 6.1999e-05 3.3 6.2e-05 0 6.3999e-05 0 6.4e-05 3.3 6.6999e-05 3.3 6.7e-05 0 6.8999e-05 0 6.9e-05 3.3 6.9999e-05 3.3 7e-05 0 7.1999e-05 0 7.2e-05 3.3 7.2999e-05 3.3 7.3e-05 0 7.3999e-05 0 7.4e-05 3.3 7.4999e-05 3.3 7.5e-05 0 7.6999e-05 0 7.7e-05 3.3 8.3999e-05 3.3 8.4e-05 0 8.5999e-05 0 8.6e-05 3.3 8.6999e-05 3.3 8.7e-05 0 8.7999e-05 0 8.8e-05 3.3 8.8999e-05 3.3 8.9e-05 0 9.0999e-05 0 9.1e-05 3.3 9.1999e-05 3.3 9.2e-05 0 9.3999e-05 0 9.4e-05 3.3 9.5999e-05 3.3 9.6e-05 0 9.8999e-05 0 9.9e-05 3.3 0.000100999 3.3 0.000101 0 0.000101999 0 0.000102 3.3 0.000103999 3.3 0.000104 0 0.000104999 0 0.000105 3.3 0.000105999 3.3 0.000106 0 0.000106999 0 0.000107 3.3 0.000108999 3.3 0.000109 0 0.000115999 0 0.000116 3.3 0.000117999 3.3 0.000118 0 0.000118999 0 0.000119 3.3 0.000119999 3.3 0.00012 0 0.000120999 0 0.000121 3.3 0.000122999 3.3 0.000123 0 0.000123999 0 0.000124 3.3 0.000125999 3.3 0.000126 0 0.000127999 0 0.000128 3.3 0.000130999 3.3 0.000131 0 0.000132999 0 0.000133 3.3 0.000133999 3.3 0.000134 0 0.000135999 0 0.000136 3.3 0.000136999 3.3 0.000137 0 0.000137999 0 0.000138 3.3 0.000138999 3.3 0.000139 0 0.000140999 0 0.000141 3.3 0.000147999 3.3 0.000148 0 0.000149999 0 0.00015 3.3 0.000150999 3.3 0.000151 0 0.000151999 0 0.000152 3.3 0.000152999 3.3 0.000153 0 0.000154999 0 0.000155 3.3 0.000155999 3.3 0.000156 0 0.000157999 0 0.000158 3.3 0.000159999 3.3 0.00016 0 0.000162999 0 0.000163 3.3 0.000164999 3.3 0.000165 0 0.000165999 0 0.000166 3.3 0.000167999 3.3 0.000168 0 0.000168999 0 0.000169 3.3 0.000169999 3.3 0.00017 0 0.000170999 0 0.000171 3.3 0.000172999 3.3 0.000173 0 0.000179999 0 0.00018 3.3 0.000181999 3.3 0.000182 0 0.000182999 0 0.000183 3.3 0.000183999 3.3 0.000184 0 0.000184999 0 0.000185 3.3 0.000186999 3.3 0.000187 0 0.000187999 0 0.000188 3.3 0.000189999 3.3 0.00019 0 0.000191999 0 0.000192 3.3 0.000194999 3.3 0.000195 0 0.000196999 0 0.000197 3.3 0.000197999 3.3 0.000198 0 0.000199999 0 0.0002 3.3 0.000200999 3.3 0.000201 0 0.000201999 0 0.000202 3.3 0.000202999 3.3 0.000203 0 0.000204999 0 0.000205 3.3 0.000211999 3.3 0.000212 0 0.000213999 0 0.000214 3.3 0.000214999 3.3 0.000215 0 0.000215999 0 0.000216 3.3 0.000216999 3.3 0.000217 0 0.000218999 0 0.000219 3.3 0.000219999 3.3 0.00022 0 0.000221999 0 0.000222 3.3 0.000223999 3.3 0.000224 0 0.000226999 0 0.000227 3.3 0.000228999 3.3 0.000229 0 0.000229999 0 0.00023 3.3 0.000231999 3.3 0.000232 0 0.000232999 0 0.000233 3.3 0.000233999 3.3 0.000234 0 0.000234999 0 0.000235 3.3 0.000236999 3.3 0.000237 0 0.000243999 0 0.000244 3.3 0.000245999 3.3 0.000246 0 0.000246999 0 0.000247 3.3 0.000247999 3.3 0.000248 0 0.000248999 0 0.000249 3.3 0.000250999 3.3 0.000251 0 0.000251999 0 0.000252 3.3 0.000253999 3.3 0.000254 0 0.000256 0)
V15 B_R[4] GND PWL(0 0 1.999e-06 0 2e-06 3.3 2.999e-06 3.3 3e-06 0 3.999e-06 0 4e-06 3.3 5.999e-06 3.3 6e-06 0 6.999e-06 0 7e-06 3.3 8.999e-06 3.3 9e-06 0 1.0999e-05 0 1.1e-05 3.3 2.1999e-05 3.3 2.2e-05 0 2.3999e-05 0 2.4e-05 3.3 2.5999e-05 3.3 2.6e-05 0 2.6999e-05 0 2.7e-05 3.3 2.8999e-05 3.3 2.9e-05 0 2.9999e-05 0 3e-05 3.3 3.0999e-05 3.3 3.1e-05 0 3.2999e-05 0 3.3e-05 3.3 3.3999e-05 3.3 3.4e-05 0 3.4999e-05 0 3.5e-05 3.3 3.5999e-05 3.3 3.6e-05 0 3.7999e-05 0 3.8e-05 3.3 3.8999e-05 3.3 3.9e-05 0 4.0999e-05 0 4.1e-05 3.3 4.2999e-05 3.3 4.3e-05 0 5.3999e-05 0 5.4e-05 3.3 5.5999e-05 3.3 5.6e-05 0 5.7999e-05 0 5.8e-05 3.3 5.8999e-05 3.3 5.9e-05 0 6.0999e-05 0 6.1e-05 3.3 6.1999e-05 3.3 6.2e-05 0 6.2999e-05 0 6.3e-05 3.3 6.4999e-05 3.3 6.5e-05 0 6.5999e-05 0 6.6e-05 3.3 6.6999e-05 3.3 6.7e-05 0 6.7999e-05 0 6.8e-05 3.3 6.9999e-05 3.3 7e-05 0 7.0999e-05 0 7.1e-05 3.3 7.2999e-05 3.3 7.3e-05 0 7.4999e-05 0 7.5e-05 3.3 8.5999e-05 3.3 8.6e-05 0 8.7999e-05 0 8.8e-05 3.3 8.9999e-05 3.3 9e-05 0 9.0999e-05 0 9.1e-05 3.3 9.2999e-05 3.3 9.3e-05 0 9.3999e-05 0 9.4e-05 3.3 9.4999e-05 3.3 9.5e-05 0 9.6999e-05 0 9.7e-05 3.3 9.7999e-05 3.3 9.8e-05 0 9.8999e-05 0 9.9e-05 3.3 9.9999e-05 3.3 0.0001 0 0.000101999 0 0.000102 3.3 0.000102999 3.3 0.000103 0 0.000104999 0 0.000105 3.3 0.000106999 3.3 0.000107 0 0.000117999 0 0.000118 3.3 0.000119999 3.3 0.00012 0 0.000121999 0 0.000122 3.3 0.000122999 3.3 0.000123 0 0.000124999 0 0.000125 3.3 0.000125999 3.3 0.000126 0 0.000126999 0 0.000127 3.3 0.000128999 3.3 0.000129 0 0.000129999 0 0.00013 3.3 0.000130999 3.3 0.000131 0 0.000131999 0 0.000132 3.3 0.000133999 3.3 0.000134 0 0.000134999 0 0.000135 3.3 0.000136999 3.3 0.000137 0 0.000138999 0 0.000139 3.3 0.000149999 3.3 0.00015 0 0.000151999 0 0.000152 3.3 0.000153999 3.3 0.000154 0 0.000154999 0 0.000155 3.3 0.000156999 3.3 0.000157 0 0.000157999 0 0.000158 3.3 0.000158999 3.3 0.000159 0 0.000160999 0 0.000161 3.3 0.000161999 3.3 0.000162 0 0.000162999 0 0.000163 3.3 0.000163999 3.3 0.000164 0 0.000165999 0 0.000166 3.3 0.000166999 3.3 0.000167 0 0.000168999 0 0.000169 3.3 0.000170999 3.3 0.000171 0 0.000181999 0 0.000182 3.3 0.000183999 3.3 0.000184 0 0.000185999 0 0.000186 3.3 0.000186999 3.3 0.000187 0 0.000188999 0 0.000189 3.3 0.000189999 3.3 0.00019 0 0.000190999 0 0.000191 3.3 0.000192999 3.3 0.000193 0 0.000193999 0 0.000194 3.3 0.000194999 3.3 0.000195 0 0.000195999 0 0.000196 3.3 0.000197999 3.3 0.000198 0 0.000198999 0 0.000199 3.3 0.000200999 3.3 0.000201 0 0.000202999 0 0.000203 3.3 0.000213999 3.3 0.000214 0 0.000215999 0 0.000216 3.3 0.000217999 3.3 0.000218 0 0.000218999 0 0.000219 3.3 0.000220999 3.3 0.000221 0 0.000221999 0 0.000222 3.3 0.000222999 3.3 0.000223 0 0.000224999 0 0.000225 3.3 0.000225999 3.3 0.000226 0 0.000226999 0 0.000227 3.3 0.000227999 3.3 0.000228 0 0.000229999 0 0.00023 3.3 0.000230999 3.3 0.000231 0 0.000232999 0 0.000233 3.3 0.000234999 3.3 0.000235 0 0.000245999 0 0.000246 3.3 0.000247999 3.3 0.000248 0 0.000249999 0 0.00025 3.3 0.000250999 3.3 0.000251 0 0.000252999 0 0.000253 3.3 0.000253999 3.3 0.000254 0 0.000254999 0 0.000255 3.3 0.000256 3.3)
V16 B_R[5] GND PWL(0 0 2.999e-06 0 3e-06 3.3 5.999e-06 3.3 6e-06 0 8.999e-06 0 9e-06 3.3 2.3999e-05 3.3 2.4e-05 0 2.6999e-05 0 2.7e-05 3.3 2.9999e-05 3.3 3e-05 0 3.2999e-05 0 3.3e-05 3.3 3.4999e-05 3.3 3.5e-05 0 3.7999e-05 0 3.8e-05 3.3 4.0999e-05 3.3 4.1e-05 0 5.5999e-05 0 5.6e-05 3.3 5.8999e-05 3.3 5.9e-05 0 6.1999e-05 0 6.2e-05 3.3 6.4999e-05 3.3 6.5e-05 0 6.6999e-05 0 6.7e-05 3.3 6.9999e-05 3.3 7e-05 0 7.2999e-05 0 7.3e-05 3.3 8.7999e-05 3.3 8.8e-05 0 9.0999e-05 0 9.1e-05 3.3 9.3999e-05 3.3 9.4e-05 0 9.6999e-05 0 9.7e-05 3.3 9.8999e-05 3.3 9.9e-05 0 0.000101999 0 0.000102 3.3 0.000104999 3.3 0.000105 0 0.000119999 0 0.00012 3.3 0.000122999 3.3 0.000123 0 0.000125999 0 0.000126 3.3 0.000128999 3.3 0.000129 0 0.000130999 0 0.000131 3.3 0.000133999 3.3 0.000134 0 0.000136999 0 0.000137 3.3 0.000151999 3.3 0.000152 0 0.000154999 0 0.000155 3.3 0.000157999 3.3 0.000158 0 0.000160999 0 0.000161 3.3 0.000162999 3.3 0.000163 0 0.000165999 0 0.000166 3.3 0.000168999 3.3 0.000169 0 0.000183999 0 0.000184 3.3 0.000186999 3.3 0.000187 0 0.000189999 0 0.00019 3.3 0.000192999 3.3 0.000193 0 0.000194999 0 0.000195 3.3 0.000197999 3.3 0.000198 0 0.000200999 0 0.000201 3.3 0.000215999 3.3 0.000216 0 0.000218999 0 0.000219 3.3 0.000221999 3.3 0.000222 0 0.000224999 0 0.000225 3.3 0.000226999 3.3 0.000227 0 0.000229999 0 0.00023 3.3 0.000232999 3.3 0.000233 0 0.000247999 0 0.000248 3.3 0.000250999 3.3 0.000251 0 0.000253999 0 0.000254 3.3 0.000256 3.3)
V17 B_R[6] GND PWL(0 0 5.999e-06 0 6e-06 3.3 2.6999e-05 3.3 2.7e-05 0 3.2999e-05 0 3.3e-05 3.3 3.7999e-05 3.3 3.8e-05 0 5.8999e-05 0 5.9e-05 3.3 6.4999e-05 3.3 6.5e-05 0 6.9999e-05 0 7e-05 3.3 9.0999e-05 3.3 9.1e-05 0 9.6999e-05 0 9.7e-05 3.3 0.000101999 3.3 0.000102 0 0.000122999 0 0.000123 3.3 0.000128999 3.3 0.000129 0 0.000133999 0 0.000134 3.3 0.000154999 3.3 0.000155 0 0.000160999 0 0.000161 3.3 0.000165999 3.3 0.000166 0 0.000186999 0 0.000187 3.3 0.000192999 3.3 0.000193 0 0.000197999 0 0.000198 3.3 0.000218999 3.3 0.000219 0 0.000224999 0 0.000225 3.3 0.000229999 3.3 0.00023 0 0.000250999 0 0.000251 3.3 0.000256 3.3)
V18 B_R[7] GND PWL(0 3.3 3.2999e-05 3.3 3.3e-05 0 6.4999e-05 0 6.5e-05 3.3 9.6999e-05 3.3 9.7e-05 0 0.000128999 0 0.000129 3.3 0.000160999 3.3 0.000161 0 0.000192999 0 0.000193 3.3 0.000224999 3.3 0.000225 0 0.000256 0)
