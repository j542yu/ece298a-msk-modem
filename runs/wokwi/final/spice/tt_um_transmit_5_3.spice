* NGSPICE file created from tt_um_transmit_5_3.ext - technology: gf180mcuD

* Black-box entry subcircuit for gf180mcu_fd_sc_mcu7t5v0__fillcap_4 abstract view
.subckt gf180mcu_fd_sc_mcu7t5v0__fillcap_4 VDD VNW VPW VSS
.ends

* Black-box entry subcircuit for gf180mcu_fd_sc_mcu7t5v0__fill_2 abstract view
.subckt gf180mcu_fd_sc_mcu7t5v0__fill_2 VDD VNW VPW VSS
.ends

* Black-box entry subcircuit for gf180mcu_fd_sc_mcu7t5v0__or2_1 abstract view
.subckt gf180mcu_fd_sc_mcu7t5v0__or2_1 A1 A2 Z VDD VNW VPW VSS
.ends

* Black-box entry subcircuit for gf180mcu_fd_sc_mcu7t5v0__nor2_2 abstract view
.subckt gf180mcu_fd_sc_mcu7t5v0__nor2_2 A1 A2 ZN VDD VNW VPW VSS
.ends

* Black-box entry subcircuit for gf180mcu_fd_sc_mcu7t5v0__oai31_1 abstract view
.subckt gf180mcu_fd_sc_mcu7t5v0__oai31_1 A1 A2 A3 B ZN VDD VNW VPW VSS
.ends

* Black-box entry subcircuit for gf180mcu_fd_sc_mcu7t5v0__filltie abstract view
.subckt gf180mcu_fd_sc_mcu7t5v0__filltie VDD VSS
.ends

* Black-box entry subcircuit for gf180mcu_fd_sc_mcu7t5v0__endcap abstract view
.subckt gf180mcu_fd_sc_mcu7t5v0__endcap VDD VSS
.ends

* Black-box entry subcircuit for gf180mcu_fd_sc_mcu7t5v0__nor3_4 abstract view
.subckt gf180mcu_fd_sc_mcu7t5v0__nor3_4 A1 A2 A3 ZN VDD VNW VPW VSS
.ends

* Black-box entry subcircuit for gf180mcu_fd_sc_mcu7t5v0__oai21_4 abstract view
.subckt gf180mcu_fd_sc_mcu7t5v0__oai21_4 A1 A2 B ZN VDD VNW VPW VSS
.ends

* Black-box entry subcircuit for gf180mcu_fd_sc_mcu7t5v0__fill_1 abstract view
.subckt gf180mcu_fd_sc_mcu7t5v0__fill_1 VDD VNW VPW VSS
.ends

* Black-box entry subcircuit for gf180mcu_fd_sc_mcu7t5v0__xor2_1 abstract view
.subckt gf180mcu_fd_sc_mcu7t5v0__xor2_1 A1 A2 Z VDD VNW VPW VSS
.ends

* Black-box entry subcircuit for gf180mcu_fd_sc_mcu7t5v0__xnor2_1 abstract view
.subckt gf180mcu_fd_sc_mcu7t5v0__xnor2_1 A1 A2 ZN VDD VNW VPW VSS
.ends

* Black-box entry subcircuit for gf180mcu_fd_sc_mcu7t5v0__fillcap_16 abstract view
.subckt gf180mcu_fd_sc_mcu7t5v0__fillcap_16 VDD VNW VPW VSS
.ends

* Black-box entry subcircuit for gf180mcu_fd_sc_mcu7t5v0__aoi22_4 abstract view
.subckt gf180mcu_fd_sc_mcu7t5v0__aoi22_4 A1 A2 B1 B2 ZN VDD VNW VPW VSS
.ends

* Black-box entry subcircuit for gf180mcu_fd_sc_mcu7t5v0__nand2_2 abstract view
.subckt gf180mcu_fd_sc_mcu7t5v0__nand2_2 A1 A2 ZN VDD VNW VPW VSS
.ends

* Black-box entry subcircuit for gf180mcu_fd_sc_mcu7t5v0__oai21_1 abstract view
.subckt gf180mcu_fd_sc_mcu7t5v0__oai21_1 A1 A2 B ZN VDD VNW VPW VSS
.ends

* Black-box entry subcircuit for gf180mcu_fd_sc_mcu7t5v0__oai21_2 abstract view
.subckt gf180mcu_fd_sc_mcu7t5v0__oai21_2 A1 A2 B ZN VDD VNW VPW VSS
.ends

* Black-box entry subcircuit for gf180mcu_fd_sc_mcu7t5v0__oai32_4 abstract view
.subckt gf180mcu_fd_sc_mcu7t5v0__oai32_4 A1 A2 A3 B1 B2 ZN VDD VNW VPW VSS
.ends

* Black-box entry subcircuit for gf180mcu_fd_sc_mcu7t5v0__clkbuf_1 abstract view
.subckt gf180mcu_fd_sc_mcu7t5v0__clkbuf_1 I Z VDD VNW VPW VSS
.ends

* Black-box entry subcircuit for gf180mcu_fd_sc_mcu7t5v0__aoi21_1 abstract view
.subckt gf180mcu_fd_sc_mcu7t5v0__aoi21_1 A1 A2 B ZN VDD VNW VPW VSS
.ends

* Black-box entry subcircuit for gf180mcu_fd_sc_mcu7t5v0__clkinv_8 abstract view
.subckt gf180mcu_fd_sc_mcu7t5v0__clkinv_8 I ZN VDD VNW VPW VSS
.ends

* Black-box entry subcircuit for gf180mcu_fd_sc_mcu7t5v0__nor2_1 abstract view
.subckt gf180mcu_fd_sc_mcu7t5v0__nor2_1 A1 A2 ZN VDD VNW VPW VSS
.ends

* Black-box entry subcircuit for gf180mcu_fd_sc_mcu7t5v0__aoi22_1 abstract view
.subckt gf180mcu_fd_sc_mcu7t5v0__aoi22_1 A1 A2 B1 B2 ZN VDD VNW VPW VSS
.ends

* Black-box entry subcircuit for gf180mcu_fd_sc_mcu7t5v0__or3_4 abstract view
.subckt gf180mcu_fd_sc_mcu7t5v0__or3_4 A1 A2 A3 Z VDD VNW VPW VSS
.ends

* Black-box entry subcircuit for gf180mcu_fd_sc_mcu7t5v0__buf_2 abstract view
.subckt gf180mcu_fd_sc_mcu7t5v0__buf_2 I Z VDD VNW VPW VSS
.ends

* Black-box entry subcircuit for gf180mcu_fd_sc_mcu7t5v0__fillcap_8 abstract view
.subckt gf180mcu_fd_sc_mcu7t5v0__fillcap_8 VDD VNW VPW VSS
.ends

* Black-box entry subcircuit for gf180mcu_fd_sc_mcu7t5v0__nand3_4 abstract view
.subckt gf180mcu_fd_sc_mcu7t5v0__nand3_4 A1 A2 A3 ZN VDD VNW VPW VSS
.ends

* Black-box entry subcircuit for gf180mcu_fd_sc_mcu7t5v0__nand2_1 abstract view
.subckt gf180mcu_fd_sc_mcu7t5v0__nand2_1 A1 A2 ZN VDD VNW VPW VSS
.ends

* Black-box entry subcircuit for gf180mcu_fd_sc_mcu7t5v0__nor3_2 abstract view
.subckt gf180mcu_fd_sc_mcu7t5v0__nor3_2 A1 A2 A3 ZN VDD VNW VPW VSS
.ends

* Black-box entry subcircuit for gf180mcu_fd_sc_mcu7t5v0__buf_4 abstract view
.subckt gf180mcu_fd_sc_mcu7t5v0__buf_4 I Z VDD VNW VPW VSS
.ends

* Black-box entry subcircuit for gf180mcu_fd_sc_mcu7t5v0__nor4_4 abstract view
.subckt gf180mcu_fd_sc_mcu7t5v0__nor4_4 A1 A2 A3 A4 ZN VDD VNW VPW VSS
.ends

* Black-box entry subcircuit for gf180mcu_fd_sc_mcu7t5v0__dffrnq_1 abstract view
.subckt gf180mcu_fd_sc_mcu7t5v0__dffrnq_1 D RN CLK Q VDD VNW VPW VSS
.ends

* Black-box entry subcircuit for gf180mcu_fd_sc_mcu7t5v0__nand3_2 abstract view
.subckt gf180mcu_fd_sc_mcu7t5v0__nand3_2 A1 A2 A3 ZN VDD VNW VPW VSS
.ends

* Black-box entry subcircuit for gf180mcu_fd_sc_mcu7t5v0__or2_4 abstract view
.subckt gf180mcu_fd_sc_mcu7t5v0__or2_4 A1 A2 Z VDD VNW VPW VSS
.ends

* Black-box entry subcircuit for gf180mcu_fd_sc_mcu7t5v0__clkbuf_2 abstract view
.subckt gf180mcu_fd_sc_mcu7t5v0__clkbuf_2 I Z VDD VNW VPW VSS
.ends

* Black-box entry subcircuit for gf180mcu_fd_sc_mcu7t5v0__oai211_1 abstract view
.subckt gf180mcu_fd_sc_mcu7t5v0__oai211_1 A1 A2 B C ZN VDD VNW VPW VSS
.ends

* Black-box entry subcircuit for gf180mcu_fd_sc_mcu7t5v0__dffrnq_2 abstract view
.subckt gf180mcu_fd_sc_mcu7t5v0__dffrnq_2 D RN CLK Q VDD VNW VPW VSS
.ends

* Black-box entry subcircuit for gf180mcu_fd_sc_mcu7t5v0__nor3_1 abstract view
.subckt gf180mcu_fd_sc_mcu7t5v0__nor3_1 A1 A2 A3 ZN VDD VNW VPW VSS
.ends

* Black-box entry subcircuit for gf180mcu_fd_sc_mcu7t5v0__oai211_2 abstract view
.subckt gf180mcu_fd_sc_mcu7t5v0__oai211_2 A1 A2 B C ZN VDD VNW VPW VSS
.ends

* Black-box entry subcircuit for gf180mcu_fd_sc_mcu7t5v0__nor2_4 abstract view
.subckt gf180mcu_fd_sc_mcu7t5v0__nor2_4 A1 A2 ZN VDD VNW VPW VSS
.ends

* Black-box entry subcircuit for gf180mcu_fd_sc_mcu7t5v0__oai31_4 abstract view
.subckt gf180mcu_fd_sc_mcu7t5v0__oai31_4 A1 A2 A3 B ZN VDD VNW VPW VSS
.ends

* Black-box entry subcircuit for gf180mcu_fd_sc_mcu7t5v0__nand4_1 abstract view
.subckt gf180mcu_fd_sc_mcu7t5v0__nand4_1 A1 A2 A3 A4 ZN VDD VNW VPW VSS
.ends

* Black-box entry subcircuit for gf180mcu_fd_sc_mcu7t5v0__oai221_4 abstract view
.subckt gf180mcu_fd_sc_mcu7t5v0__oai221_4 A1 A2 B1 B2 C ZN VDD VNW VPW VSS
.ends

* Black-box entry subcircuit for gf180mcu_fd_sc_mcu7t5v0__clkinv_1 abstract view
.subckt gf180mcu_fd_sc_mcu7t5v0__clkinv_1 I ZN VDD VNW VPW VSS
.ends

* Black-box entry subcircuit for gf180mcu_fd_sc_mcu7t5v0__oai221_1 abstract view
.subckt gf180mcu_fd_sc_mcu7t5v0__oai221_1 A1 A2 B1 B2 C ZN VDD VNW VPW VSS
.ends

* Black-box entry subcircuit for gf180mcu_fd_sc_mcu7t5v0__xor3_1 abstract view
.subckt gf180mcu_fd_sc_mcu7t5v0__xor3_1 A1 A2 A3 Z VDD VNW VPW VSS
.ends

* Black-box entry subcircuit for gf180mcu_fd_sc_mcu7t5v0__inv_2 abstract view
.subckt gf180mcu_fd_sc_mcu7t5v0__inv_2 I ZN VDD VNW VPW VSS
.ends

* Black-box entry subcircuit for gf180mcu_fd_sc_mcu7t5v0__dlyb_1 abstract view
.subckt gf180mcu_fd_sc_mcu7t5v0__dlyb_1 I Z VDD VNW VPW VSS
.ends

* Black-box entry subcircuit for gf180mcu_fd_sc_mcu7t5v0__clkbuf_16 abstract view
.subckt gf180mcu_fd_sc_mcu7t5v0__clkbuf_16 I Z VDD VNW VPW VSS
.ends

* Black-box entry subcircuit for gf180mcu_fd_sc_mcu7t5v0__nand3_1 abstract view
.subckt gf180mcu_fd_sc_mcu7t5v0__nand3_1 A1 A2 A3 ZN VDD VNW VPW VSS
.ends

* Black-box entry subcircuit for gf180mcu_fd_sc_mcu7t5v0__nand4_4 abstract view
.subckt gf180mcu_fd_sc_mcu7t5v0__nand4_4 A1 A2 A3 A4 ZN VDD VNW VPW VSS
.ends

* Black-box entry subcircuit for gf180mcu_fd_sc_mcu7t5v0__or4_2 abstract view
.subckt gf180mcu_fd_sc_mcu7t5v0__or4_2 A1 A2 A3 A4 Z VDD VNW VPW VSS
.ends

* Black-box entry subcircuit for gf180mcu_fd_sc_mcu7t5v0__aoi211_2 abstract view
.subckt gf180mcu_fd_sc_mcu7t5v0__aoi211_2 A1 A2 B C ZN VDD VNW VPW VSS
.ends

* Black-box entry subcircuit for gf180mcu_fd_sc_mcu7t5v0__and4_1 abstract view
.subckt gf180mcu_fd_sc_mcu7t5v0__and4_1 A1 A2 A3 A4 Z VDD VNW VPW VSS
.ends

* Black-box entry subcircuit for gf180mcu_fd_sc_mcu7t5v0__aoi21_2 abstract view
.subckt gf180mcu_fd_sc_mcu7t5v0__aoi21_2 A1 A2 B ZN VDD VNW VPW VSS
.ends

* Black-box entry subcircuit for gf180mcu_fd_sc_mcu7t5v0__clkbuf_4 abstract view
.subckt gf180mcu_fd_sc_mcu7t5v0__clkbuf_4 I Z VDD VNW VPW VSS
.ends

* Black-box entry subcircuit for gf180mcu_fd_sc_mcu7t5v0__buf_1 abstract view
.subckt gf180mcu_fd_sc_mcu7t5v0__buf_1 I Z VDD VNW VPW VSS
.ends

* Black-box entry subcircuit for gf180mcu_fd_sc_mcu7t5v0__dffrnq_4 abstract view
.subckt gf180mcu_fd_sc_mcu7t5v0__dffrnq_4 D RN CLK Q VDD VNW VPW VSS
.ends

* Black-box entry subcircuit for gf180mcu_fd_sc_mcu7t5v0__aoi211_1 abstract view
.subckt gf180mcu_fd_sc_mcu7t5v0__aoi211_1 A1 A2 B C ZN VDD VNW VPW VSS
.ends

* Black-box entry subcircuit for gf180mcu_fd_sc_mcu7t5v0__and2_1 abstract view
.subckt gf180mcu_fd_sc_mcu7t5v0__and2_1 A1 A2 Z VDD VNW VPW VSS
.ends

* Black-box entry subcircuit for gf180mcu_fd_sc_mcu7t5v0__or4_4 abstract view
.subckt gf180mcu_fd_sc_mcu7t5v0__or4_4 A1 A2 A3 A4 Z VDD VNW VPW VSS
.ends

* Black-box entry subcircuit for gf180mcu_fd_sc_mcu7t5v0__and3_1 abstract view
.subckt gf180mcu_fd_sc_mcu7t5v0__and3_1 A1 A2 A3 Z VDD VNW VPW VSS
.ends

* Black-box entry subcircuit for gf180mcu_fd_sc_mcu7t5v0__xor2_2 abstract view
.subckt gf180mcu_fd_sc_mcu7t5v0__xor2_2 A1 A2 Z VDD VNW VPW VSS
.ends

* Black-box entry subcircuit for gf180mcu_fd_sc_mcu7t5v0__buf_8 abstract view
.subckt gf180mcu_fd_sc_mcu7t5v0__buf_8 I Z VDD VNW VPW VSS
.ends

* Black-box entry subcircuit for gf180mcu_fd_sc_mcu7t5v0__buf_3 abstract view
.subckt gf180mcu_fd_sc_mcu7t5v0__buf_3 I Z VDD VNW VPW VSS
.ends

* Black-box entry subcircuit for gf180mcu_fd_sc_mcu7t5v0__oai22_1 abstract view
.subckt gf180mcu_fd_sc_mcu7t5v0__oai22_1 A1 A2 B1 B2 ZN VDD VNW VPW VSS
.ends

* Black-box entry subcircuit for gf180mcu_fd_sc_mcu7t5v0__and4_2 abstract view
.subckt gf180mcu_fd_sc_mcu7t5v0__and4_2 A1 A2 A3 A4 Z VDD VNW VPW VSS
.ends

* Black-box entry subcircuit for gf180mcu_fd_sc_mcu7t5v0__nand4_2 abstract view
.subckt gf180mcu_fd_sc_mcu7t5v0__nand4_2 A1 A2 A3 A4 ZN VDD VNW VPW VSS
.ends

* Black-box entry subcircuit for gf180mcu_fd_sc_mcu7t5v0__and3_2 abstract view
.subckt gf180mcu_fd_sc_mcu7t5v0__and3_2 A1 A2 A3 Z VDD VNW VPW VSS
.ends

* Black-box entry subcircuit for gf180mcu_fd_sc_mcu7t5v0__or3_1 abstract view
.subckt gf180mcu_fd_sc_mcu7t5v0__or3_1 A1 A2 A3 Z VDD VNW VPW VSS
.ends

* Black-box entry subcircuit for gf180mcu_fd_sc_mcu7t5v0__aoi21_4 abstract view
.subckt gf180mcu_fd_sc_mcu7t5v0__aoi21_4 A1 A2 B ZN VDD VNW VPW VSS
.ends

* Black-box entry subcircuit for gf180mcu_fd_sc_mcu7t5v0__nand2_4 abstract view
.subckt gf180mcu_fd_sc_mcu7t5v0__nand2_4 A1 A2 ZN VDD VNW VPW VSS
.ends

* Black-box entry subcircuit for gf180mcu_fd_sc_mcu7t5v0__aoi221_4 abstract view
.subckt gf180mcu_fd_sc_mcu7t5v0__aoi221_4 A1 A2 B1 B2 C ZN VDD VNW VPW VSS
.ends

* Black-box entry subcircuit for gf180mcu_fd_sc_mcu7t5v0__oai211_4 abstract view
.subckt gf180mcu_fd_sc_mcu7t5v0__oai211_4 A1 A2 B C ZN VDD VNW VPW VSS
.ends

* Black-box entry subcircuit for gf180mcu_fd_sc_mcu7t5v0__oai31_2 abstract view
.subckt gf180mcu_fd_sc_mcu7t5v0__oai31_2 A1 A2 A3 B ZN VDD VNW VPW VSS
.ends

* Black-box entry subcircuit for gf180mcu_fd_sc_mcu7t5v0__mux2_2 abstract view
.subckt gf180mcu_fd_sc_mcu7t5v0__mux2_2 I0 I1 S Z VDD VNW VPW VSS
.ends

* Black-box entry subcircuit for gf180mcu_fd_sc_mcu7t5v0__xor2_4 abstract view
.subckt gf180mcu_fd_sc_mcu7t5v0__xor2_4 A1 A2 Z VDD VNW VPW VSS
.ends

* Black-box entry subcircuit for gf180mcu_fd_sc_mcu7t5v0__xnor2_2 abstract view
.subckt gf180mcu_fd_sc_mcu7t5v0__xnor2_2 A1 A2 ZN VDD VNW VPW VSS
.ends

* Black-box entry subcircuit for gf180mcu_fd_sc_mcu7t5v0__or4_1 abstract view
.subckt gf180mcu_fd_sc_mcu7t5v0__or4_1 A1 A2 A3 A4 Z VDD VNW VPW VSS
.ends

* Black-box entry subcircuit for gf180mcu_fd_sc_mcu7t5v0__aoi222_2 abstract view
.subckt gf180mcu_fd_sc_mcu7t5v0__aoi222_2 A1 A2 B1 B2 C1 C2 ZN VDD VNW VPW VSS
.ends

* Black-box entry subcircuit for gf180mcu_fd_sc_mcu7t5v0__fillcap_32 abstract view
.subckt gf180mcu_fd_sc_mcu7t5v0__fillcap_32 VDD VNW VPW VSS
.ends

* Black-box entry subcircuit for gf180mcu_fd_sc_mcu7t5v0__and3_4 abstract view
.subckt gf180mcu_fd_sc_mcu7t5v0__and3_4 A1 A2 A3 Z VDD VNW VPW VSS
.ends

* Black-box entry subcircuit for gf180mcu_fd_sc_mcu7t5v0__aoi22_2 abstract view
.subckt gf180mcu_fd_sc_mcu7t5v0__aoi22_2 A1 A2 B1 B2 ZN VDD VNW VPW VSS
.ends

* Black-box entry subcircuit for gf180mcu_fd_sc_mcu7t5v0__aoi221_1 abstract view
.subckt gf180mcu_fd_sc_mcu7t5v0__aoi221_1 A1 A2 B1 B2 C ZN VDD VNW VPW VSS
.ends

* Black-box entry subcircuit for gf180mcu_fd_sc_mcu7t5v0__clkbuf_8 abstract view
.subckt gf180mcu_fd_sc_mcu7t5v0__clkbuf_8 I Z VDD VNW VPW VSS
.ends

* Black-box entry subcircuit for gf180mcu_fd_sc_mcu7t5v0__aoi211_4 abstract view
.subckt gf180mcu_fd_sc_mcu7t5v0__aoi211_4 A1 A2 B C ZN VDD VNW VPW VSS
.ends

.subckt tt_um_transmit_5_3 B[0] B[1] B[2] B[3] B[4] T[0] T[1] T[2] T[3] T[4] T[5]
+ T[6] VGND VPWR clk enable in rst_n
XFILLER_22_199 VPWR VPWR VGND VGND gf180mcu_fd_sc_mcu7t5v0__fillcap_4
XFILLER_22_122 VPWR VPWR VGND VGND gf180mcu_fd_sc_mcu7t5v0__fill_2
XFILLER_22_100 VPWR VPWR VGND VGND gf180mcu_fd_sc_mcu7t5v0__fill_2
X_432_ _387_/Z _420_/Z _432_/Z VPWR VPWR VGND VGND gf180mcu_fd_sc_mcu7t5v0__or2_1
X_363_ _388_/B _515_/C _496_/B2 VPWR VPWR VGND VGND gf180mcu_fd_sc_mcu7t5v0__nor2_2
X_501_ _504_/A2 _501_/A2 _501_/A3 _501_/B _511_/A2 VPWR VPWR VGND VGND gf180mcu_fd_sc_mcu7t5v0__oai31_1
XFILLER_9_159 VPWR VPWR VGND VGND gf180mcu_fd_sc_mcu7t5v0__fill_2
XTAP_TAPCELL_ROW_20_120 VPWR VGND gf180mcu_fd_sc_mcu7t5v0__filltie
XPHY_EDGE_ROW_0_Left_23 VPWR VGND gf180mcu_fd_sc_mcu7t5v0__endcap
X_415_ _392_/Z _321_/Z _415_/A3 _501_/B VPWR VPWR VGND VGND gf180mcu_fd_sc_mcu7t5v0__nor3_4
XTAP_TAPCELL_ROW_8_77 VPWR VGND gf180mcu_fd_sc_mcu7t5v0__filltie
X_346_ _346_/A1 _336_/Z _346_/B _505_/A2 VPWR VPWR VGND VGND gf180mcu_fd_sc_mcu7t5v0__oai21_4
XFILLER_21_209 VPWR VPWR VGND VGND gf180mcu_fd_sc_mcu7t5v0__fill_1
X_329_ _330_/A1 _576_/B _329_/Z VPWR VPWR VGND VGND gf180mcu_fd_sc_mcu7t5v0__xor2_1
XFILLER_20_242 VPWR VPWR VGND VGND gf180mcu_fd_sc_mcu7t5v0__fill_2
XTAP_TAPCELL_ROW_5_67 VPWR VGND gf180mcu_fd_sc_mcu7t5v0__filltie
XFILLER_7_235 VPWR VPWR VGND VGND gf180mcu_fd_sc_mcu7t5v0__fill_1
X_594_ _592_/Z _605_/A2 _596_/A2 VPWR VPWR VGND VGND gf180mcu_fd_sc_mcu7t5v0__xnor2_1
XFILLER_4_249 VPWR VPWR VGND VGND gf180mcu_fd_sc_mcu7t5v0__fill_1
XTAP_TAPCELL_ROW_18_115 VPWR VGND gf180mcu_fd_sc_mcu7t5v0__filltie
XFILLER_16_164 VPWR VPWR VGND VGND gf180mcu_fd_sc_mcu7t5v0__fill_1
X_577_ _581_/A1 _589_/A2 _577_/Z VPWR VPWR VGND VGND gf180mcu_fd_sc_mcu7t5v0__xor2_1
XTAP_TAPCELL_ROW_2_57 VPWR VGND gf180mcu_fd_sc_mcu7t5v0__filltie
XFILLER_22_178 VPWR VPWR VGND VGND gf180mcu_fd_sc_mcu7t5v0__fillcap_16
X_431_ _412_/B _519_/A1 _486_/B wire38/Z _531_/A1 VPWR VPWR VGND VGND gf180mcu_fd_sc_mcu7t5v0__aoi22_4
X_362_ _379_/A1 _480_/A2 _515_/C VPWR VPWR VGND VGND gf180mcu_fd_sc_mcu7t5v0__nand2_2
X_500_ _364_/C _500_/A2 _500_/B _510_/A2 VPWR VPWR VGND VGND gf180mcu_fd_sc_mcu7t5v0__oai21_1
XTAP_TAPCELL_ROW_20_121 VPWR VGND gf180mcu_fd_sc_mcu7t5v0__filltie
XTAP_TAPCELL_ROW_8_78 VPWR VGND gf180mcu_fd_sc_mcu7t5v0__filltie
X_414_ _338_/Z _533_/A2 _515_/B _538_/A3 VPWR VPWR VGND VGND gf180mcu_fd_sc_mcu7t5v0__oai21_2
X_345_ _369_/B _533_/C _340_/Z _377_/B _310_/Z _391_/A1 VPWR VPWR VGND VGND gf180mcu_fd_sc_mcu7t5v0__oai32_4
XPHY_EDGE_ROW_21_Right_21 VPWR VGND gf180mcu_fd_sc_mcu7t5v0__endcap
XPHY_EDGE_ROW_12_Right_12 VPWR VGND gf180mcu_fd_sc_mcu7t5v0__endcap
X_328_ _335_/B _301_/I _331_/B _330_/A1 VPWR VPWR VGND VGND gf180mcu_fd_sc_mcu7t5v0__oai21_2
XFILLER_18_32 VPWR VPWR VGND VGND gf180mcu_fd_sc_mcu7t5v0__fill_2
XTAP_TAPCELL_ROW_5_68 VPWR VGND gf180mcu_fd_sc_mcu7t5v0__filltie
Xload_slew20 _504_/A1 _471_/B VPWR VPWR VGND VGND gf180mcu_fd_sc_mcu7t5v0__clkbuf_1
X_593_ _577_/Z _593_/A2 _593_/B _605_/A2 VPWR VPWR VGND VGND gf180mcu_fd_sc_mcu7t5v0__aoi21_1
XFILLER_1_209 VPWR VPWR VGND VGND gf180mcu_fd_sc_mcu7t5v0__fill_1
XPHY_EDGE_ROW_6_Right_6 VPWR VGND gf180mcu_fd_sc_mcu7t5v0__endcap
X_576_ _335_/B _576_/A2 _576_/B _581_/A2 VPWR VPWR VGND VGND gf180mcu_fd_sc_mcu7t5v0__oai21_1
XTAP_TAPCELL_ROW_2_58 VPWR VGND gf180mcu_fd_sc_mcu7t5v0__filltie
XFILLER_22_146 VPWR VPWR VGND VGND gf180mcu_fd_sc_mcu7t5v0__fill_1
X_430_ _430_/I _456_/A1 VPWR VPWR VGND VGND gf180mcu_fd_sc_mcu7t5v0__clkinv_8
X_361_ _364_/B _500_/A2 _495_/A2 VPWR VPWR VGND VGND gf180mcu_fd_sc_mcu7t5v0__nor2_2
X_559_ _614_/Q _615_/Q _569_/A2 VPWR VPWR VGND VGND gf180mcu_fd_sc_mcu7t5v0__nor2_1
XTAP_TAPCELL_ROW_20_122 VPWR VGND gf180mcu_fd_sc_mcu7t5v0__filltie
XFILLER_18_238 VPWR VPWR VGND VGND gf180mcu_fd_sc_mcu7t5v0__fill_1
X_413_ _338_/Z _533_/A2 _526_/A3 VPWR VPWR VGND VGND gf180mcu_fd_sc_mcu7t5v0__nor2_2
XFILLER_5_142 VPWR VPWR VGND VGND gf180mcu_fd_sc_mcu7t5v0__fillcap_4
X_344_ wire37/Z _474_/B _471_/B _504_/A2 _518_/A1 VPWR VPWR VGND VGND gf180mcu_fd_sc_mcu7t5v0__aoi22_1
XTAP_TAPCELL_ROW_8_79 VPWR VGND gf180mcu_fd_sc_mcu7t5v0__filltie
XFILLER_2_156 VPWR VPWR VGND VGND gf180mcu_fd_sc_mcu7t5v0__fill_1
XFILLER_20_244 VPWR VPWR VGND VGND gf180mcu_fd_sc_mcu7t5v0__fill_1
X_327_ _327_/A1 _420_/A2 _321_/Z _369_/B VPWR VPWR VGND VGND gf180mcu_fd_sc_mcu7t5v0__or3_4
XTAP_TAPCELL_ROW_5_69 VPWR VGND gf180mcu_fd_sc_mcu7t5v0__filltie
Xload_slew21 _474_/B _412_/B VPWR VPWR VGND VGND gf180mcu_fd_sc_mcu7t5v0__buf_2
Xload_slew10 _520_/A1 _532_/B1 VPWR VPWR VGND VGND gf180mcu_fd_sc_mcu7t5v0__clkbuf_1
XFILLER_20_89 VPWR VPWR VGND VGND gf180mcu_fd_sc_mcu7t5v0__fill_2
XFILLER_20_23 VPWR VPWR VGND VGND gf180mcu_fd_sc_mcu7t5v0__fillcap_8
XFILLER_4_218 VPWR VPWR VGND VGND gf180mcu_fd_sc_mcu7t5v0__fill_1
XPHY_EDGE_ROW_16_Left_39 VPWR VGND gf180mcu_fd_sc_mcu7t5v0__endcap
X_592_ _585_/B _590_/Z _592_/Z VPWR VPWR VGND VGND gf180mcu_fd_sc_mcu7t5v0__xor2_1
XFILLER_16_111 VPWR VPWR VGND VGND gf180mcu_fd_sc_mcu7t5v0__fill_1
X_575_ _575_/A1 _575_/A2 _575_/B _589_/A2 VPWR VPWR VGND VGND gf180mcu_fd_sc_mcu7t5v0__aoi21_1
XTAP_TAPCELL_ROW_2_59 VPWR VGND gf180mcu_fd_sc_mcu7t5v0__filltie
X_360_ _394_/A1 _379_/A2 _386_/A1 _498_/A3 VPWR VPWR VGND VGND gf180mcu_fd_sc_mcu7t5v0__nand3_4
X_558_ _615_/Q _558_/A2 _615_/D VPWR VPWR VGND VGND gf180mcu_fd_sc_mcu7t5v0__xor2_1
X_489_ _504_/A2 _478_/B _497_/B VPWR VPWR VGND VGND gf180mcu_fd_sc_mcu7t5v0__nand2_1
XPHY_EDGE_ROW_19_Left_42 VPWR VGND gf180mcu_fd_sc_mcu7t5v0__endcap
X_412_ _412_/A1 _491_/A2 _412_/B _436_/A1 VPWR VPWR VGND VGND gf180mcu_fd_sc_mcu7t5v0__oai21_1
X_343_ _533_/C _340_/Z _504_/A2 VPWR VPWR VGND VGND gf180mcu_fd_sc_mcu7t5v0__nor2_2
XPHY_EDGE_ROW_4_Left_27 VPWR VGND gf180mcu_fd_sc_mcu7t5v0__endcap
X_326_ _415_/A3 _420_/A2 _321_/Z _504_/A1 VPWR VPWR VGND VGND gf180mcu_fd_sc_mcu7t5v0__nor3_2
XFILLER_18_34 VPWR VPWR VGND VGND gf180mcu_fd_sc_mcu7t5v0__fill_1
Xload_slew22 _327_/A1 _415_/A3 VPWR VPWR VGND VGND gf180mcu_fd_sc_mcu7t5v0__buf_4
X_309_ _621_/Q _309_/A2 _620_/Q _309_/A4 _461_/A1 VPWR VPWR VGND VGND gf180mcu_fd_sc_mcu7t5v0__nor4_4
XFILLER_20_46 VPWR VPWR VGND VGND gf180mcu_fd_sc_mcu7t5v0__fillcap_4
X_591_ _604_/B _590_/Z _597_/B VPWR VPWR VGND VGND gf180mcu_fd_sc_mcu7t5v0__nand2_1
XPHY_EDGE_ROW_7_Left_30 VPWR VGND gf180mcu_fd_sc_mcu7t5v0__endcap
XFILLER_15_35 VPWR VPWR VGND VGND gf180mcu_fd_sc_mcu7t5v0__fill_1
X_574_ _575_/B _574_/A2 _620_/D VPWR VPWR VGND VGND gf180mcu_fd_sc_mcu7t5v0__xor2_1
XFILLER_22_104 VPWR VPWR VGND VGND gf180mcu_fd_sc_mcu7t5v0__fill_1
X_557_ _614_/Q _557_/A2 _614_/D VPWR VPWR VGND VGND gf180mcu_fd_sc_mcu7t5v0__xnor2_1
X_626_ _626_/D _626_/RN _626_/CLK _626_/Q VPWR VPWR VGND VGND gf180mcu_fd_sc_mcu7t5v0__dffrnq_1
X_488_ _525_/A1 _488_/A2 wire9/Z _488_/A4 _490_/A4 VPWR VPWR VGND VGND gf180mcu_fd_sc_mcu7t5v0__nor4_4
XFILLER_10_107 VPWR VPWR VGND VGND gf180mcu_fd_sc_mcu7t5v0__fill_2
X_411_ _439_/A2 _444_/B _446_/A4 VPWR VPWR VGND VGND gf180mcu_fd_sc_mcu7t5v0__nand2_1
X_342_ _379_/A1 _379_/A2 _386_/A1 _498_/A2 VPWR VPWR VGND VGND gf180mcu_fd_sc_mcu7t5v0__nand3_2
X_609_ _561_/B _607_/Z _609_/B _625_/D VPWR VPWR VGND VGND gf180mcu_fd_sc_mcu7t5v0__oai21_1
XPHY_EDGE_ROW_20_Left_43 VPWR VGND gf180mcu_fd_sc_mcu7t5v0__endcap
X_325_ _415_/A3 _492_/A1 _377_/B VPWR VPWR VGND VGND gf180mcu_fd_sc_mcu7t5v0__or2_4
XFILLER_18_57 VPWR VPWR VGND VGND gf180mcu_fd_sc_mcu7t5v0__fill_2
XFILLER_18_24 VPWR VPWR VGND VGND gf180mcu_fd_sc_mcu7t5v0__fillcap_8
Xclkload0 _618_/CLK clkload0/Z VPWR VPWR VGND VGND gf180mcu_fd_sc_mcu7t5v0__clkbuf_2
XFILLER_1_2 VPWR VPWR VGND VGND gf180mcu_fd_sc_mcu7t5v0__fill_1
Xload_slew23 _505_/A2 _527_/A2 VPWR VPWR VGND VGND gf180mcu_fd_sc_mcu7t5v0__buf_2
X_308_ _575_/B _378_/A2 _533_/B VPWR VPWR VGND VGND gf180mcu_fd_sc_mcu7t5v0__nand2_1
X_590_ _623_/Q _598_/A3 _590_/Z VPWR VPWR VGND VGND gf180mcu_fd_sc_mcu7t5v0__xor2_1
XFILLER_19_154 VPWR VPWR VGND VGND gf180mcu_fd_sc_mcu7t5v0__fill_2
XTAP_TAPCELL_ROW_6_70 VPWR VGND gf180mcu_fd_sc_mcu7t5v0__filltie
X_573_ _335_/B _576_/A2 _626_/Q _626_/D _574_/A2 VPWR VPWR VGND VGND gf180mcu_fd_sc_mcu7t5v0__oai211_1
XPHY_EDGE_ROW_19_Right_19 VPWR VGND gf180mcu_fd_sc_mcu7t5v0__endcap
XFILLER_0_223 VPWR VPWR VGND VGND gf180mcu_fd_sc_mcu7t5v0__fill_1
XFILLER_22_138 VPWR VPWR VGND VGND gf180mcu_fd_sc_mcu7t5v0__fillcap_8
X_625_ _625_/D _626_/RN _626_/CLK _625_/Q VPWR VPWR VGND VGND gf180mcu_fd_sc_mcu7t5v0__dffrnq_2
XFILLER_3_28 VPWR VPWR VGND VGND gf180mcu_fd_sc_mcu7t5v0__fill_2
X_556_ _614_/Q _557_/A2 _558_/A2 VPWR VPWR VGND VGND gf180mcu_fd_sc_mcu7t5v0__nor2_1
X_487_ _487_/A1 _487_/A2 _488_/A4 VPWR VPWR VGND VGND gf180mcu_fd_sc_mcu7t5v0__nand2_1
XTAP_TAPCELL_ROW_14_100 VPWR VGND gf180mcu_fd_sc_mcu7t5v0__filltie
XTAP_TAPCELL_ROW_3_60 VPWR VGND gf180mcu_fd_sc_mcu7t5v0__filltie
X_341_ _533_/C _338_/Z _519_/A1 VPWR VPWR VGND VGND gf180mcu_fd_sc_mcu7t5v0__nor2_2
X_410_ _314_/Z _420_/A2 _464_/A2 _410_/ZN VPWR VPWR VGND VGND gf180mcu_fd_sc_mcu7t5v0__nor3_1
X_608_ _331_/B _561_/B _609_/B VPWR VPWR VGND VGND gf180mcu_fd_sc_mcu7t5v0__nand2_1
X_539_ _377_/B _387_/Z _539_/B _539_/C _540_/A1 VPWR VPWR VGND VGND gf180mcu_fd_sc_mcu7t5v0__oai211_2
X_324_ _415_/A3 _492_/A1 _474_/B VPWR VPWR VGND VGND gf180mcu_fd_sc_mcu7t5v0__nor2_4
XFILLER_20_247 VPWR VPWR VGND VGND gf180mcu_fd_sc_mcu7t5v0__fillcap_16
XTAP_TAPCELL_ROW_0_50 VPWR VGND gf180mcu_fd_sc_mcu7t5v0__filltie
XTAP_TAPCELL_ROW_9_81 VPWR VGND gf180mcu_fd_sc_mcu7t5v0__filltie
XFILLER_9_270 VPWR VPWR VGND VGND gf180mcu_fd_sc_mcu7t5v0__fill_1
Xload_slew24 _394_/A3 _476_/S VPWR VPWR VGND VGND gf180mcu_fd_sc_mcu7t5v0__clkbuf_1
Xload_slew13 _501_/B _473_/B VPWR VPWR VGND VGND gf180mcu_fd_sc_mcu7t5v0__buf_2
X_307_ _335_/B _301_/I _378_/A2 VPWR VPWR VGND VGND gf180mcu_fd_sc_mcu7t5v0__nor2_4
Xload_slew35 _496_/A1 _445_/A1 VPWR VPWR VGND VGND gf180mcu_fd_sc_mcu7t5v0__buf_2
XFILLER_20_37 VPWR VPWR VGND VGND gf180mcu_fd_sc_mcu7t5v0__fill_1
XTAP_TAPCELL_ROW_6_71 VPWR VGND gf180mcu_fd_sc_mcu7t5v0__filltie
X_572_ _619_/Q _572_/A2 _619_/D VPWR VPWR VGND VGND gf180mcu_fd_sc_mcu7t5v0__xor2_1
X_624_ _624_/D _626_/RN _626_/CLK _624_/Q VPWR VPWR VGND VGND gf180mcu_fd_sc_mcu7t5v0__dffrnq_1
X_555_ _557_/A2 _555_/A2 _613_/D VPWR VPWR VGND VGND gf180mcu_fd_sc_mcu7t5v0__nand2_1
XTAP_TAPCELL_ROW_14_101 VPWR VGND gf180mcu_fd_sc_mcu7t5v0__filltie
X_486_ _486_/A1 _486_/A2 _486_/B _487_/A2 VPWR VPWR VGND VGND gf180mcu_fd_sc_mcu7t5v0__oai21_1
XTAP_TAPCELL_ROW_3_61 VPWR VGND gf180mcu_fd_sc_mcu7t5v0__filltie
X_607_ _607_/A1 _606_/Z _607_/Z VPWR VPWR VGND VGND gf180mcu_fd_sc_mcu7t5v0__xor2_1
X_340_ _566_/A1 _346_/A1 _336_/Z _340_/Z VPWR VPWR VGND VGND gf180mcu_fd_sc_mcu7t5v0__or3_4
X_538_ _541_/A1 _541_/A2 _538_/A3 _538_/B _539_/B VPWR VPWR VGND VGND gf180mcu_fd_sc_mcu7t5v0__oai31_4
X_469_ _469_/A1 _506_/B _469_/A3 _542_/A3 _525_/A1 VPWR VPWR VGND VGND gf180mcu_fd_sc_mcu7t5v0__nand4_1
X_323_ _599_/A1 _392_/A1 _323_/B1 _323_/B2 _323_/C _492_/A1 VPWR VPWR VGND VGND gf180mcu_fd_sc_mcu7t5v0__oai221_4
XTAP_TAPCELL_ROW_0_51 VPWR VGND gf180mcu_fd_sc_mcu7t5v0__filltie
XTAP_TAPCELL_ROW_9_82 VPWR VGND gf180mcu_fd_sc_mcu7t5v0__filltie
XFILLER_18_37 VPWR VPWR VGND VGND gf180mcu_fd_sc_mcu7t5v0__fill_2
X_306_ _585_/B _604_/B VPWR VPWR VGND VGND gf180mcu_fd_sc_mcu7t5v0__clkinv_1
Xload_slew36 wire37/Z _316_/A1 VPWR VPWR VGND VGND gf180mcu_fd_sc_mcu7t5v0__buf_4
XFILLER_19_156 VPWR VPWR VGND VGND gf180mcu_fd_sc_mcu7t5v0__fill_1
XTAP_TAPCELL_ROW_6_72 VPWR VGND gf180mcu_fd_sc_mcu7t5v0__filltie
X_571_ _561_/B _576_/A2 _572_/A2 VPWR VPWR VGND VGND gf180mcu_fd_sc_mcu7t5v0__nor2_1
XPHY_EDGE_ROW_1_Right_1 VPWR VGND gf180mcu_fd_sc_mcu7t5v0__endcap
XTAP_TAPCELL_ROW_17_110 VPWR VGND gf180mcu_fd_sc_mcu7t5v0__filltie
X_623_ _623_/D _626_/RN _626_/CLK _623_/Q VPWR VPWR VGND VGND gf180mcu_fd_sc_mcu7t5v0__dffrnq_1
X_554_ _612_/Q _561_/B _548_/Z _613_/Q _555_/A2 VPWR VPWR VGND VGND gf180mcu_fd_sc_mcu7t5v0__oai31_1
XTAP_TAPCELL_ROW_3_62 VPWR VGND gf180mcu_fd_sc_mcu7t5v0__filltie
X_485_ _566_/A1 _533_/C _340_/Z _332_/Z _485_/C _486_/A2 VPWR VPWR VGND VGND gf180mcu_fd_sc_mcu7t5v0__oai221_1
X_468_ _501_/A2 _520_/B2 _542_/A3 VPWR VPWR VGND VGND gf180mcu_fd_sc_mcu7t5v0__nand2_1
X_537_ _537_/A1 _537_/A2 _540_/A2 VPWR VPWR VGND VGND gf180mcu_fd_sc_mcu7t5v0__nand2_1
X_606_ _331_/B _604_/B _606_/A3 _606_/Z VPWR VPWR VGND VGND gf180mcu_fd_sc_mcu7t5v0__xor3_1
X_399_ _439_/A1 _444_/A1 _427_/A1 VPWR VPWR VGND VGND gf180mcu_fd_sc_mcu7t5v0__nand2_1
X_322_ _323_/B1 _323_/B2 _464_/A2 VPWR VPWR VGND VGND gf180mcu_fd_sc_mcu7t5v0__nor2_2
XFILLER_20_238 VPWR VPWR VGND VGND gf180mcu_fd_sc_mcu7t5v0__fillcap_4
XTAP_TAPCELL_ROW_0_52 VPWR VGND gf180mcu_fd_sc_mcu7t5v0__filltie
XTAP_TAPCELL_ROW_9_83 VPWR VGND gf180mcu_fd_sc_mcu7t5v0__filltie
X_305_ _624_/Q _599_/A1 VPWR VPWR VGND VGND gf180mcu_fd_sc_mcu7t5v0__inv_2
Xload_slew15 _410_/ZN _530_/A2 VPWR VPWR VGND VGND gf180mcu_fd_sc_mcu7t5v0__dlyb_1
XTAP_TAPCELL_ROW_6_73 VPWR VGND gf180mcu_fd_sc_mcu7t5v0__filltie
XPHY_EDGE_ROW_11_Left_34 VPWR VGND gf180mcu_fd_sc_mcu7t5v0__endcap
X_570_ _548_/Z _560_/Z _570_/B _575_/A2 VPWR VPWR VGND VGND gf180mcu_fd_sc_mcu7t5v0__oai21_1
XFILLER_18_190 VPWR VPWR VGND VGND gf180mcu_fd_sc_mcu7t5v0__fill_2
XTAP_TAPCELL_ROW_17_111 VPWR VGND gf180mcu_fd_sc_mcu7t5v0__filltie
Xclkbuf_0_clk clk clkbuf_0_clk/Z VPWR VPWR VGND VGND gf180mcu_fd_sc_mcu7t5v0__clkbuf_16
XFILLER_15_193 VPWR VPWR VGND VGND gf180mcu_fd_sc_mcu7t5v0__fill_2
XPHY_EDGE_ROW_15_Right_15 VPWR VGND gf180mcu_fd_sc_mcu7t5v0__endcap
X_553_ _626_/D _626_/Q _569_/A1 _557_/A2 VPWR VPWR VGND VGND gf180mcu_fd_sc_mcu7t5v0__nand3_1
X_484_ _529_/A1 _484_/A2 _487_/A1 VPWR VPWR VGND VGND gf180mcu_fd_sc_mcu7t5v0__nand2_1
XFILLER_12_185 VPWR VPWR VGND VGND gf180mcu_fd_sc_mcu7t5v0__fill_2
X_622_ _622_/D _626_/RN _626_/CLK _622_/Q VPWR VPWR VGND VGND gf180mcu_fd_sc_mcu7t5v0__dffrnq_1
X_467_ _530_/B _486_/B _469_/A3 VPWR VPWR VGND VGND gf180mcu_fd_sc_mcu7t5v0__nand2_1
X_605_ _592_/Z _605_/A2 _600_/Z _605_/B _607_/A1 VPWR VPWR VGND VGND gf180mcu_fd_sc_mcu7t5v0__oai31_1
X_536_ wire8/Z _536_/A2 _531_/Z _535_/Z B[3] VPWR VPWR VGND VGND gf180mcu_fd_sc_mcu7t5v0__nand4_4
X_398_ _498_/A2 _483_/B _500_/B _398_/A4 _444_/A1 VPWR VPWR VGND VGND gf180mcu_fd_sc_mcu7t5v0__nand4_1
Xfanout40 _625_/Q _331_/B VPWR VPWR VGND VGND gf180mcu_fd_sc_mcu7t5v0__buf_4
X_321_ _323_/B1 _323_/B2 _321_/Z VPWR VPWR VGND VGND gf180mcu_fd_sc_mcu7t5v0__or2_4
XFILLER_14_247 VPWR VPWR VGND VGND gf180mcu_fd_sc_mcu7t5v0__fill_1
XFILLER_13_50 VPWR VPWR VGND VGND gf180mcu_fd_sc_mcu7t5v0__fill_1
XFILLER_18_39 VPWR VPWR VGND VGND gf180mcu_fd_sc_mcu7t5v0__fill_1
X_519_ _519_/A1 _541_/A2 _532_/B2 _519_/A4 _519_/Z VPWR VPWR VGND VGND gf180mcu_fd_sc_mcu7t5v0__or4_2
XFILLER_10_261 VPWR VPWR VGND VGND gf180mcu_fd_sc_mcu7t5v0__fill_2
X_304_ _622_/Q _581_/B VPWR VPWR VGND VGND gf180mcu_fd_sc_mcu7t5v0__clkinv_1
XTAP_TAPCELL_ROW_10_84 VPWR VGND gf180mcu_fd_sc_mcu7t5v0__filltie
X_552_ _610_/Q _611_/Q _612_/Q _613_/Q _569_/A1 VPWR VPWR VGND VGND gf180mcu_fd_sc_mcu7t5v0__aoi211_2
X_483_ _340_/Z _483_/A2 _483_/B _484_/A2 VPWR VPWR VGND VGND gf180mcu_fd_sc_mcu7t5v0__oai21_1
X_621_ _621_/D _626_/RN _626_/CLK _621_/Q VPWR VPWR VGND VGND gf180mcu_fd_sc_mcu7t5v0__dffrnq_2
X_397_ _483_/B _395_/Z _528_/A1 VPWR VPWR VGND VGND gf180mcu_fd_sc_mcu7t5v0__nand2_1
X_604_ _590_/Z _599_/Z _604_/B _605_/B VPWR VPWR VGND VGND gf180mcu_fd_sc_mcu7t5v0__oai21_1
X_466_ _480_/A2 _483_/A2 _532_/B1 _506_/B VPWR VPWR VGND VGND gf180mcu_fd_sc_mcu7t5v0__nand3_1
X_535_ _535_/A1 _535_/A2 _535_/A3 _535_/A4 _535_/Z VPWR VPWR VGND VGND gf180mcu_fd_sc_mcu7t5v0__and4_1
XTAP_TAPCELL_ROW_13_95 VPWR VGND gf180mcu_fd_sc_mcu7t5v0__filltie
XFILLER_22_270 VPWR VPWR VGND VGND gf180mcu_fd_sc_mcu7t5v0__fill_1
X_320_ _625_/Q _310_/Z _581_/B _323_/B2 VPWR VPWR VGND VGND gf180mcu_fd_sc_mcu7t5v0__aoi21_2
Xfanout30 _329_/Z _364_/B VPWR VPWR VGND VGND gf180mcu_fd_sc_mcu7t5v0__clkbuf_4
Xfanout41 _619_/Q _309_/A4 VPWR VPWR VGND VGND gf180mcu_fd_sc_mcu7t5v0__buf_4
XFILLER_20_229 VPWR VPWR VGND VGND gf180mcu_fd_sc_mcu7t5v0__fillcap_4
X_518_ _518_/A1 _518_/A2 _525_/A4 VPWR VPWR VGND VGND gf180mcu_fd_sc_mcu7t5v0__nand2_1
X_449_ _453_/A3 _454_/A2 T[0] VPWR VPWR VGND VGND gf180mcu_fd_sc_mcu7t5v0__nor2_4
Xload_slew39 wire38/I _496_/A1 VPWR VPWR VGND VGND gf180mcu_fd_sc_mcu7t5v0__clkbuf_2
XFILLER_11_229 VPWR VPWR VGND VGND gf180mcu_fd_sc_mcu7t5v0__fill_2
XFILLER_11_218 VPWR VPWR VGND VGND gf180mcu_fd_sc_mcu7t5v0__fill_1
Xload_slew17 _401_/ZN _541_/B VPWR VPWR VGND VGND gf180mcu_fd_sc_mcu7t5v0__buf_1
XFILLER_6_244 VPWR VPWR VGND VGND gf180mcu_fd_sc_mcu7t5v0__fill_1
X_303_ _621_/Q _581_/A1 VPWR VPWR VGND VGND gf180mcu_fd_sc_mcu7t5v0__clkinv_1
XTAP_TAPCELL_ROW_10_85 VPWR VGND gf180mcu_fd_sc_mcu7t5v0__filltie
XFILLER_18_192 VPWR VPWR VGND VGND gf180mcu_fd_sc_mcu7t5v0__fill_1
XFILLER_21_62 VPWR VPWR VGND VGND gf180mcu_fd_sc_mcu7t5v0__fill_2
XFILLER_16_107 VPWR VPWR VGND VGND gf180mcu_fd_sc_mcu7t5v0__fillcap_4
XFILLER_15_195 VPWR VPWR VGND VGND gf180mcu_fd_sc_mcu7t5v0__fill_1
X_551_ _612_/Q _551_/A2 _612_/D VPWR VPWR VGND VGND gf180mcu_fd_sc_mcu7t5v0__xor2_1
X_620_ _620_/D _626_/RN _626_/CLK _620_/Q VPWR VPWR VGND VGND gf180mcu_fd_sc_mcu7t5v0__dffrnq_4
XPHY_EDGE_ROW_5_Right_5 VPWR VGND gf180mcu_fd_sc_mcu7t5v0__endcap
X_482_ _364_/C _340_/Z _506_/A2 _503_/B _482_/B2 wire9/I VPWR VPWR VGND VGND gf180mcu_fd_sc_mcu7t5v0__oai32_4
XTAP_TAPCELL_ROW_20_119 VPWR VGND gf180mcu_fd_sc_mcu7t5v0__filltie
X_603_ _603_/A1 _601_/Z _603_/B _624_/D VPWR VPWR VGND VGND gf180mcu_fd_sc_mcu7t5v0__oai21_1
X_465_ _321_/Z _504_/B2 _503_/B VPWR VPWR VGND VGND gf180mcu_fd_sc_mcu7t5v0__nand2_1
X_534_ _538_/B _534_/A2 _534_/B _534_/C _535_/A4 VPWR VPWR VGND VGND gf180mcu_fd_sc_mcu7t5v0__aoi211_1
X_396_ _500_/B _398_/A4 _425_/A2 VPWR VPWR VGND VGND gf180mcu_fd_sc_mcu7t5v0__nand2_1
XTAP_TAPCELL_ROW_13_96 VPWR VGND gf180mcu_fd_sc_mcu7t5v0__filltie
XFILLER_1_142 VPWR VPWR VGND VGND gf180mcu_fd_sc_mcu7t5v0__fill_2
Xfanout31 _329_/Z _527_/A1 VPWR VPWR VGND VGND gf180mcu_fd_sc_mcu7t5v0__buf_1
Xfanout42 _618_/Q _309_/A2 VPWR VPWR VGND VGND gf180mcu_fd_sc_mcu7t5v0__buf_4
X_448_ _448_/I _453_/A3 VPWR VPWR VGND VGND gf180mcu_fd_sc_mcu7t5v0__inv_2
X_517_ _517_/A1 _517_/A2 _517_/A3 _517_/A4 _525_/A2 VPWR VPWR VGND VGND gf180mcu_fd_sc_mcu7t5v0__nand4_1
X_379_ _379_/A1 _379_/A2 _483_/A2 VPWR VPWR VGND VGND gf180mcu_fd_sc_mcu7t5v0__nor2_1
Xload_slew29 _330_/Z _379_/A1 VPWR VPWR VGND VGND gf180mcu_fd_sc_mcu7t5v0__buf_4
X_302_ _576_/B _575_/B VPWR VPWR VGND VGND gf180mcu_fd_sc_mcu7t5v0__inv_2
XFILLER_1_88 VPWR VPWR VGND VGND gf180mcu_fd_sc_mcu7t5v0__fill_1
XTAP_TAPCELL_ROW_10_86 VPWR VGND gf180mcu_fd_sc_mcu7t5v0__filltie
XFILLER_21_52 VPWR VPWR VGND VGND gf180mcu_fd_sc_mcu7t5v0__fill_2
XPHY_EDGE_ROW_15_Left_38 VPWR VGND gf180mcu_fd_sc_mcu7t5v0__endcap
X_550_ _603_/A1 _548_/Z _551_/A2 VPWR VPWR VGND VGND gf180mcu_fd_sc_mcu7t5v0__nor2_1
XPHY_EDGE_ROW_20_Right_20 VPWR VGND gf180mcu_fd_sc_mcu7t5v0__endcap
X_481_ _491_/A2 _532_/B2 _481_/A3 _482_/B2 VPWR VPWR VGND VGND gf180mcu_fd_sc_mcu7t5v0__nor3_2
XFILLER_12_144 VPWR VPWR VGND VGND gf180mcu_fd_sc_mcu7t5v0__fill_2
XPHY_EDGE_ROW_11_Right_11 VPWR VGND gf180mcu_fd_sc_mcu7t5v0__endcap
X_602_ _624_/Q _603_/A1 _603_/B VPWR VPWR VGND VGND gf180mcu_fd_sc_mcu7t5v0__nand2_1
XFILLER_17_269 VPWR VPWR VGND VGND gf180mcu_fd_sc_mcu7t5v0__fill_2
X_533_ _338_/Z _533_/A2 _533_/B _533_/C _534_/A2 VPWR VPWR VGND VGND gf180mcu_fd_sc_mcu7t5v0__oai211_1
X_464_ _314_/Z _464_/A2 _392_/Z _520_/A1 VPWR VPWR VGND VGND gf180mcu_fd_sc_mcu7t5v0__nor3_2
XFILLER_4_173 VPWR VPWR VGND VGND gf180mcu_fd_sc_mcu7t5v0__fill_2
X_395_ _500_/B _398_/A4 _395_/Z VPWR VPWR VGND VGND gf180mcu_fd_sc_mcu7t5v0__and2_1
Xfanout32 _545_/ZN _603_/A1 VPWR VPWR VGND VGND gf180mcu_fd_sc_mcu7t5v0__dlyb_1
Xfanout43 _618_/Q _346_/B VPWR VPWR VGND VGND gf180mcu_fd_sc_mcu7t5v0__buf_2
XPHY_EDGE_ROW_18_Left_41 VPWR VGND gf180mcu_fd_sc_mcu7t5v0__endcap
XTAP_TAPCELL_ROW_13_97 VPWR VGND gf180mcu_fd_sc_mcu7t5v0__filltie
X_447_ _447_/A1 _447_/A2 _391_/Z _450_/A2 VPWR VPWR VGND VGND gf180mcu_fd_sc_mcu7t5v0__nor3_4
XFILLER_8_2 VPWR VPWR VGND VGND gf180mcu_fd_sc_mcu7t5v0__fill_1
X_516_ _418_/B _516_/A2 _517_/A4 VPWR VPWR VGND VGND gf180mcu_fd_sc_mcu7t5v0__nand2_1
X_378_ _576_/B _378_/A2 _385_/A2 _493_/A2 VPWR VPWR VGND VGND gf180mcu_fd_sc_mcu7t5v0__nand3_4
XPHY_EDGE_ROW_3_Left_26 VPWR VGND gf180mcu_fd_sc_mcu7t5v0__endcap
X_301_ _301_/I _566_/A1 VPWR VPWR VGND VGND gf180mcu_fd_sc_mcu7t5v0__inv_2
Xload_slew19 _393_/ZN _495_/B VPWR VPWR VGND VGND gf180mcu_fd_sc_mcu7t5v0__clkbuf_1
XTAP_TAPCELL_ROW_10_87 VPWR VGND gf180mcu_fd_sc_mcu7t5v0__filltie
XFILLER_19_30 VPWR VPWR VGND VGND gf180mcu_fd_sc_mcu7t5v0__fillcap_4
XFILLER_15_142 VPWR VPWR VGND VGND gf180mcu_fd_sc_mcu7t5v0__fill_2
XFILLER_16_42 VPWR VPWR VGND VGND gf180mcu_fd_sc_mcu7t5v0__fill_2
X_480_ _533_/A2 _480_/A2 _481_/A3 VPWR VPWR VGND VGND gf180mcu_fd_sc_mcu7t5v0__nor2_1
X_601_ _601_/A1 _600_/Z _601_/Z VPWR VPWR VGND VGND gf180mcu_fd_sc_mcu7t5v0__xor2_1
X_463_ _529_/A1 _463_/A2 _469_/A1 VPWR VPWR VGND VGND gf180mcu_fd_sc_mcu7t5v0__nand2_1
Xload_slew6 _456_/A3 _448_/I VPWR VPWR VGND VGND gf180mcu_fd_sc_mcu7t5v0__buf_2
X_532_ _532_/A1 _478_/B _532_/B1 _532_/B2 _535_/A3 VPWR VPWR VGND VGND gf180mcu_fd_sc_mcu7t5v0__aoi22_1
X_394_ _394_/A1 _332_/Z _394_/A3 _398_/A4 VPWR VPWR VGND VGND gf180mcu_fd_sc_mcu7t5v0__nand3_1
XFILLER_22_240 VPWR VPWR VGND VGND gf180mcu_fd_sc_mcu7t5v0__fillcap_16
Xfanout33 _545_/ZN _561_/B VPWR VPWR VGND VGND gf180mcu_fd_sc_mcu7t5v0__dlyb_1
XFILLER_16_270 VPWR VPWR VGND VGND gf180mcu_fd_sc_mcu7t5v0__fill_1
Xfanout11 _523_/A2 _486_/B VPWR VPWR VGND VGND gf180mcu_fd_sc_mcu7t5v0__buf_4
Xfanout44 input3/Z _626_/RN VPWR VPWR VGND VGND gf180mcu_fd_sc_mcu7t5v0__dlyb_1
X_446_ _446_/A1 _446_/A2 _446_/A3 _446_/A4 _447_/A1 VPWR VPWR VGND VGND gf180mcu_fd_sc_mcu7t5v0__nand4_1
XFILLER_1_144 VPWR VPWR VGND VGND gf180mcu_fd_sc_mcu7t5v0__fill_1
XTAP_TAPCELL_ROW_0_46 VPWR VGND gf180mcu_fd_sc_mcu7t5v0__filltie
X_515_ _566_/A1 _330_/Z _515_/B _515_/C _516_/A2 VPWR VPWR VGND VGND gf180mcu_fd_sc_mcu7t5v0__oai211_1
X_377_ _485_/C _509_/A2 _377_/B _534_/C VPWR VPWR VGND VGND gf180mcu_fd_sc_mcu7t5v0__aoi21_1
X_300_ _335_/B _575_/A1 VPWR VPWR VGND VGND gf180mcu_fd_sc_mcu7t5v0__clkinv_1
XFILLER_10_232 VPWR VPWR VGND VGND gf180mcu_fd_sc_mcu7t5v0__fill_2
X_429_ _429_/A1 _543_/A1 _391_/Z _429_/A4 _430_/I VPWR VPWR VGND VGND gf180mcu_fd_sc_mcu7t5v0__or4_4
Xinput1 enable _626_/D VPWR VPWR VGND VGND gf180mcu_fd_sc_mcu7t5v0__dlyb_1
XFILLER_18_151 VPWR VPWR VGND VGND gf180mcu_fd_sc_mcu7t5v0__fill_2
XFILLER_16_2 VPWR VPWR VGND VGND gf180mcu_fd_sc_mcu7t5v0__fill_2
XTAP_TAPCELL_ROW_22_130 VPWR VGND gf180mcu_fd_sc_mcu7t5v0__filltie
XFILLER_12_146 VPWR VPWR VGND VGND gf180mcu_fd_sc_mcu7t5v0__fill_1
XPHY_EDGE_ROW_9_Right_9 VPWR VGND gf180mcu_fd_sc_mcu7t5v0__endcap
X_600_ _585_/B _599_/Z _600_/Z VPWR VPWR VGND VGND gf180mcu_fd_sc_mcu7t5v0__xor2_1
X_531_ _531_/A1 _537_/A2 _531_/A3 _531_/Z VPWR VPWR VGND VGND gf180mcu_fd_sc_mcu7t5v0__and3_1
XFILLER_4_24 VPWR VPWR VGND VGND gf180mcu_fd_sc_mcu7t5v0__fill_1
Xload_slew7 _450_/A2 _456_/A3 VPWR VPWR VGND VGND gf180mcu_fd_sc_mcu7t5v0__buf_4
X_462_ _527_/B1 _493_/A2 _505_/B _463_/A2 VPWR VPWR VGND VGND gf180mcu_fd_sc_mcu7t5v0__nand3_1
Xclone51 _401_/ZN _478_/B VPWR VPWR VGND VGND gf180mcu_fd_sc_mcu7t5v0__buf_1
X_393_ _415_/A3 _464_/A2 _392_/Z _393_/ZN VPWR VPWR VGND VGND gf180mcu_fd_sc_mcu7t5v0__nor3_4
Xfanout45 input3/Z _619_/RN VPWR VPWR VGND VGND gf180mcu_fd_sc_mcu7t5v0__dlyb_1
XTAP_TAPCELL_ROW_0_47 VPWR VGND gf180mcu_fd_sc_mcu7t5v0__filltie
Xfanout34 _461_/A1 wire38/I VPWR VPWR VGND VGND gf180mcu_fd_sc_mcu7t5v0__buf_2
X_514_ _538_/B _514_/A2 _514_/B _517_/A3 VPWR VPWR VGND VGND gf180mcu_fd_sc_mcu7t5v0__aoi21_1
X_376_ _501_/A2 _376_/A2 _509_/A2 VPWR VPWR VGND VGND gf180mcu_fd_sc_mcu7t5v0__nor2_1
XFILLER_9_212 VPWR VPWR VGND VGND gf180mcu_fd_sc_mcu7t5v0__fillcap_4
X_445_ _445_/A1 _418_/B _486_/B _446_/A1 VPWR VPWR VGND VGND gf180mcu_fd_sc_mcu7t5v0__aoi21_1
X_359_ _379_/A1 _359_/A2 _338_/Z _541_/A2 VPWR VPWR VGND VGND gf180mcu_fd_sc_mcu7t5v0__nor3_4
X_428_ _428_/A1 _436_/A1 _428_/A3 _440_/A1 _429_/A4 VPWR VPWR VGND VGND gf180mcu_fd_sc_mcu7t5v0__nand4_1
Xinput2 in _585_/B VPWR VPWR VGND VGND gf180mcu_fd_sc_mcu7t5v0__dlyb_1
XTAP_TAPCELL_ROW_22_131 VPWR VGND gf180mcu_fd_sc_mcu7t5v0__filltie
XFILLER_12_103 VPWR VPWR VGND VGND gf180mcu_fd_sc_mcu7t5v0__fill_2
X_392_ _392_/A1 _599_/A1 _392_/Z VPWR VPWR VGND VGND gf180mcu_fd_sc_mcu7t5v0__xor2_2
X_530_ _495_/B _530_/A2 _530_/B _531_/A3 VPWR VPWR VGND VGND gf180mcu_fd_sc_mcu7t5v0__oai21_1
X_461_ _461_/A1 _461_/A2 _474_/B _490_/A3 VPWR VPWR VGND VGND gf180mcu_fd_sc_mcu7t5v0__oai21_1
XFILLER_22_264 VPWR VPWR VGND VGND gf180mcu_fd_sc_mcu7t5v0__fillcap_4
XTAP_TAPCELL_ROW_0_48 VPWR VGND gf180mcu_fd_sc_mcu7t5v0__filltie
X_444_ _444_/A1 _444_/A2 _538_/A3 _444_/B _446_/A3 VPWR VPWR VGND VGND gf180mcu_fd_sc_mcu7t5v0__oai31_1
X_375_ _515_/B _475_/A2 _521_/B2 VPWR VPWR VGND VGND gf180mcu_fd_sc_mcu7t5v0__nand2_1
X_513_ _483_/B _500_/B _485_/C _499_/B _514_/A2 VPWR VPWR VGND VGND gf180mcu_fd_sc_mcu7t5v0__nand4_1
X_427_ _427_/A1 _517_/A1 _446_/A4 _429_/A1 VPWR VPWR VGND VGND gf180mcu_fd_sc_mcu7t5v0__nand3_1
XFILLER_10_234 VPWR VPWR VGND VGND gf180mcu_fd_sc_mcu7t5v0__fill_1
X_358_ _619_/Q _566_/A1 _500_/A2 VPWR VPWR VGND VGND gf180mcu_fd_sc_mcu7t5v0__nand2_1
XPHY_EDGE_ROW_18_Right_18 VPWR VGND gf180mcu_fd_sc_mcu7t5v0__endcap
Xinput3 rst_n input3/Z VPWR VPWR VGND VGND gf180mcu_fd_sc_mcu7t5v0__dlyb_1
XFILLER_19_55 VPWR VPWR VGND VGND gf180mcu_fd_sc_mcu7t5v0__fill_2
XFILLER_19_22 VPWR VPWR VGND VGND gf180mcu_fd_sc_mcu7t5v0__fillcap_8
XFILLER_18_153 VPWR VPWR VGND VGND gf180mcu_fd_sc_mcu7t5v0__fill_1
XFILLER_16_4 VPWR VPWR VGND VGND gf180mcu_fd_sc_mcu7t5v0__fill_1
XTAP_TAPCELL_ROW_22_132 VPWR VGND gf180mcu_fd_sc_mcu7t5v0__filltie
XPHY_EDGE_ROW_0_Right_0 VPWR VGND gf180mcu_fd_sc_mcu7t5v0__endcap
XFILLER_17_207 VPWR VPWR VGND VGND gf180mcu_fd_sc_mcu7t5v0__fill_2
X_391_ _391_/A1 _391_/A2 _534_/C _534_/B _391_/Z VPWR VPWR VGND VGND gf180mcu_fd_sc_mcu7t5v0__or4_4
X_460_ wire38/Z _530_/B _478_/B _490_/A2 VPWR VPWR VGND VGND gf180mcu_fd_sc_mcu7t5v0__oai21_1
X_589_ _621_/Q _589_/A2 _623_/Q _622_/Q _599_/A2 VPWR VPWR VGND VGND gf180mcu_fd_sc_mcu7t5v0__oai211_1
XFILLER_4_199 VPWR VPWR VGND VGND gf180mcu_fd_sc_mcu7t5v0__fill_2
XFILLER_22_221 VPWR VPWR VGND VGND gf180mcu_fd_sc_mcu7t5v0__fillcap_16
XTAP_TAPCELL_ROW_0_49 VPWR VGND gf180mcu_fd_sc_mcu7t5v0__filltie
Xfanout25 _333_/Z _385_/A2 VPWR VPWR VGND VGND gf180mcu_fd_sc_mcu7t5v0__buf_8
Xfanout14 _410_/ZN _444_/B VPWR VPWR VGND VGND gf180mcu_fd_sc_mcu7t5v0__buf_3
X_443_ _444_/A2 _529_/A1 _542_/A2 VPWR VPWR VGND VGND gf180mcu_fd_sc_mcu7t5v0__nand2_1
X_374_ _346_/B _379_/A1 _385_/A2 _338_/Z _475_/A2 VPWR VPWR VGND VGND gf180mcu_fd_sc_mcu7t5v0__nand4_4
X_512_ _512_/A1 _511_/Z _512_/A3 B[1] VPWR VPWR VGND VGND gf180mcu_fd_sc_mcu7t5v0__nand3_4
X_426_ _446_/A2 _426_/A2 _543_/A1 VPWR VPWR VGND VGND gf180mcu_fd_sc_mcu7t5v0__nand2_1
X_357_ _575_/A1 _301_/I _480_/A2 VPWR VPWR VGND VGND gf180mcu_fd_sc_mcu7t5v0__nor2_4
XFILLER_19_34 VPWR VPWR VGND VGND gf180mcu_fd_sc_mcu7t5v0__fill_1
X_409_ _314_/Z _420_/A2 _508_/A1 VPWR VPWR VGND VGND gf180mcu_fd_sc_mcu7t5v0__nor2_1
XTAP_TAPCELL_ROW_11_90 VPWR VGND gf180mcu_fd_sc_mcu7t5v0__filltie
XPHY_EDGE_ROW_10_Left_33 VPWR VGND gf180mcu_fd_sc_mcu7t5v0__endcap
XFILLER_14_2 VPWR VPWR VGND VGND gf180mcu_fd_sc_mcu7t5v0__fillcap_4
XFILLER_7_175 VPWR VPWR VGND VGND gf180mcu_fd_sc_mcu7t5v0__fill_2
X_390_ _377_/B _387_/Z _390_/B1 _369_/B _391_/A2 VPWR VPWR VGND VGND gf180mcu_fd_sc_mcu7t5v0__oai22_1
X_588_ _603_/A1 _587_/Z _588_/B _622_/D VPWR VPWR VGND VGND gf180mcu_fd_sc_mcu7t5v0__oai21_1
Xfanout26 _333_/Z _364_/C VPWR VPWR VGND VGND gf180mcu_fd_sc_mcu7t5v0__buf_2
X_442_ _430_/I _442_/A2 _454_/A2 VPWR VPWR VGND VGND gf180mcu_fd_sc_mcu7t5v0__nand2_2
X_373_ _364_/B _379_/A2 _505_/A2 _376_/A2 VPWR VPWR VGND VGND gf180mcu_fd_sc_mcu7t5v0__nor3_1
XFILLER_1_159 VPWR VPWR VGND VGND gf180mcu_fd_sc_mcu7t5v0__fill_2
XFILLER_1_115 VPWR VPWR VGND VGND gf180mcu_fd_sc_mcu7t5v0__fill_2
X_511_ _518_/A2 _511_/A2 _511_/A3 _511_/A4 _511_/Z VPWR VPWR VGND VGND gf180mcu_fd_sc_mcu7t5v0__and4_2
X_425_ _496_/B2 _425_/A2 _425_/A3 _486_/B _426_/A2 VPWR VPWR VGND VGND gf180mcu_fd_sc_mcu7t5v0__oai31_1
X_356_ _301_/I _330_/Z _379_/A2 _338_/Z _483_/B VPWR VPWR VGND VGND gf180mcu_fd_sc_mcu7t5v0__nand4_4
XFILLER_19_57 VPWR VPWR VGND VGND gf180mcu_fd_sc_mcu7t5v0__fill_1
XFILLER_10_26 VPWR VPWR VGND VGND gf180mcu_fd_sc_mcu7t5v0__fill_1
X_408_ _475_/A2 _493_/A2 _505_/B _386_/B _439_/A2 VPWR VPWR VGND VGND gf180mcu_fd_sc_mcu7t5v0__nand4_2
X_339_ _566_/A1 _346_/A1 _336_/Z _394_/A3 VPWR VPWR VGND VGND gf180mcu_fd_sc_mcu7t5v0__nor3_2
XFILLER_21_36 VPWR VPWR VGND VGND gf180mcu_fd_sc_mcu7t5v0__fillcap_16
XTAP_TAPCELL_ROW_17_109 VPWR VGND gf180mcu_fd_sc_mcu7t5v0__filltie
XFILLER_21_139 VPWR VPWR VGND VGND gf180mcu_fd_sc_mcu7t5v0__fill_1
XFILLER_17_209 VPWR VPWR VGND VGND gf180mcu_fd_sc_mcu7t5v0__fill_1
X_587_ _577_/Z _587_/A2 _587_/Z VPWR VPWR VGND VGND gf180mcu_fd_sc_mcu7t5v0__xor2_1
XFILLER_22_256 VPWR VPWR VGND VGND gf180mcu_fd_sc_mcu7t5v0__fillcap_8
Xfanout16 _401_/ZN _520_/B2 VPWR VPWR VGND VGND gf180mcu_fd_sc_mcu7t5v0__buf_3
Xfanout27 _332_/Z _379_/A2 VPWR VPWR VGND VGND gf180mcu_fd_sc_mcu7t5v0__buf_8
X_441_ _450_/A1 _447_/A2 _391_/Z _442_/A2 VPWR VPWR VGND VGND gf180mcu_fd_sc_mcu7t5v0__nor3_4
X_372_ _495_/A2 _364_/C _485_/C VPWR VPWR VGND VGND gf180mcu_fd_sc_mcu7t5v0__nand2_2
X_510_ _412_/B _510_/A2 _510_/B _510_/C _511_/A4 VPWR VPWR VGND VGND gf180mcu_fd_sc_mcu7t5v0__aoi211_1
XFILLER_13_37 VPWR VPWR VGND VGND gf180mcu_fd_sc_mcu7t5v0__fill_2
XFILLER_13_48 VPWR VPWR VGND VGND gf180mcu_fd_sc_mcu7t5v0__fill_2
X_424_ _445_/A1 _444_/B _446_/A2 VPWR VPWR VGND VGND gf180mcu_fd_sc_mcu7t5v0__nand2_1
X_355_ _369_/B _369_/A1 _514_/B VPWR VPWR VGND VGND gf180mcu_fd_sc_mcu7t5v0__nor2_1
XPHY_EDGE_ROW_14_Right_14 VPWR VGND gf180mcu_fd_sc_mcu7t5v0__endcap
XFILLER_4_2 VPWR VPWR VGND VGND gf180mcu_fd_sc_mcu7t5v0__fillcap_4
X_407_ _530_/B _520_/B2 _428_/A3 VPWR VPWR VGND VGND gf180mcu_fd_sc_mcu7t5v0__nand2_1
X_338_ _346_/A1 _336_/Z _338_/Z VPWR VPWR VGND VGND gf180mcu_fd_sc_mcu7t5v0__or2_4
XPHY_EDGE_ROW_4_Right_4 VPWR VGND gf180mcu_fd_sc_mcu7t5v0__endcap
X_586_ _584_/Z _593_/A2 _587_/A2 VPWR VPWR VGND VGND gf180mcu_fd_sc_mcu7t5v0__nand2_1
XFILLER_22_268 VPWR VPWR VGND VGND gf180mcu_fd_sc_mcu7t5v0__fill_2
X_371_ _332_/Z _515_/C _461_/A2 VPWR VPWR VGND VGND gf180mcu_fd_sc_mcu7t5v0__nor2_1
X_440_ _440_/A1 _539_/C _440_/A3 _440_/A4 _440_/ZN VPWR VPWR VGND VGND gf180mcu_fd_sc_mcu7t5v0__nand4_1
X_569_ _569_/A1 _569_/A2 _569_/B _576_/A2 VPWR VPWR VGND VGND gf180mcu_fd_sc_mcu7t5v0__aoi21_1
XFILLER_5_72 VPWR VPWR VGND VGND gf180mcu_fd_sc_mcu7t5v0__fill_2
X_354_ _541_/A1 _501_/A2 _369_/A1 VPWR VPWR VGND VGND gf180mcu_fd_sc_mcu7t5v0__nor2_1
X_423_ _566_/A1 _533_/C _425_/A3 VPWR VPWR VGND VGND gf180mcu_fd_sc_mcu7t5v0__nor2_1
X_406_ _445_/A1 _520_/B2 _444_/A2 _439_/A1 _517_/A1 VPWR VPWR VGND VGND gf180mcu_fd_sc_mcu7t5v0__aoi22_1
X_337_ _346_/A1 _336_/Z _386_/A1 VPWR VPWR VGND VGND gf180mcu_fd_sc_mcu7t5v0__nor2_4
XFILLER_15_138 VPWR VPWR VGND VGND gf180mcu_fd_sc_mcu7t5v0__fill_2
XFILLER_7_18 VPWR VPWR VGND VGND gf180mcu_fd_sc_mcu7t5v0__fill_2
XFILLER_22_70 VPWR VPWR VGND VGND gf180mcu_fd_sc_mcu7t5v0__fill_2
XPHY_EDGE_ROW_14_Left_37 VPWR VGND gf180mcu_fd_sc_mcu7t5v0__endcap
X_585_ _598_/A3 _585_/A2 _585_/B _593_/A2 VPWR VPWR VGND VGND gf180mcu_fd_sc_mcu7t5v0__oai21_1
XFILLER_22_203 VPWR VPWR VGND VGND gf180mcu_fd_sc_mcu7t5v0__fill_1
Xfanout18 _393_/ZN _439_/A1 VPWR VPWR VGND VGND gf180mcu_fd_sc_mcu7t5v0__buf_4
XFILLER_12_2 VPWR VPWR VGND VGND gf180mcu_fd_sc_mcu7t5v0__fill_1
XFILLER_13_39 VPWR VPWR VGND VGND gf180mcu_fd_sc_mcu7t5v0__fill_1
X_370_ _391_/A1 _534_/B _542_/A1 VPWR VPWR VGND VGND gf180mcu_fd_sc_mcu7t5v0__nor2_1
XFILLER_9_207 VPWR VPWR VGND VGND gf180mcu_fd_sc_mcu7t5v0__fill_2
X_568_ _346_/B _616_/Q _617_/Q _569_/B VPWR VPWR VGND VGND gf180mcu_fd_sc_mcu7t5v0__nand3_1
X_499_ _388_/B _340_/Z _499_/B _533_/B _507_/A2 VPWR VPWR VGND VGND gf180mcu_fd_sc_mcu7t5v0__oai211_2
XPHY_EDGE_ROW_17_Left_40 VPWR VGND gf180mcu_fd_sc_mcu7t5v0__endcap
X_422_ _425_/A2 _486_/B _517_/A2 VPWR VPWR VGND VGND gf180mcu_fd_sc_mcu7t5v0__nand2_1
X_353_ _364_/B _379_/A2 _340_/Z _515_/B _501_/A2 VPWR VPWR VGND VGND gf180mcu_fd_sc_mcu7t5v0__oai31_4
XPHY_EDGE_ROW_2_Left_25 VPWR VGND gf180mcu_fd_sc_mcu7t5v0__endcap
X_336_ _331_/B _335_/B _301_/I _336_/Z VPWR VPWR VGND VGND gf180mcu_fd_sc_mcu7t5v0__and3_2
X_405_ _527_/B1 _505_/C _444_/A2 VPWR VPWR VGND VGND gf180mcu_fd_sc_mcu7t5v0__nand2_1
X_319_ _319_/A1 _622_/Q wire37/Z _323_/B1 VPWR VPWR VGND VGND gf180mcu_fd_sc_mcu7t5v0__nor3_4
Xclkbuf_1_0__f_clk clkbuf_0_clk/Z _626_/CLK VPWR VPWR VGND VGND gf180mcu_fd_sc_mcu7t5v0__clkbuf_16
XTAP_TAPCELL_ROW_22_126 VPWR VGND gf180mcu_fd_sc_mcu7t5v0__filltie
XFILLER_22_60 VPWR VPWR VGND VGND gf180mcu_fd_sc_mcu7t5v0__fill_2
XFILLER_19_253 VPWR VPWR VGND VGND gf180mcu_fd_sc_mcu7t5v0__fillcap_16
X_584_ _585_/B _598_/A3 _585_/A2 _584_/Z VPWR VPWR VGND VGND gf180mcu_fd_sc_mcu7t5v0__or3_1
XTAP_TAPCELL_ROW_4_63 VPWR VGND gf180mcu_fd_sc_mcu7t5v0__filltie
XFILLER_22_237 VPWR VPWR VGND VGND gf180mcu_fd_sc_mcu7t5v0__fill_1
XFILLER_21_270 VPWR VPWR VGND VGND gf180mcu_fd_sc_mcu7t5v0__fill_1
X_567_ _346_/B _616_/Q _617_/Q _570_/B VPWR VPWR VGND VGND gf180mcu_fd_sc_mcu7t5v0__and3_1
X_498_ _340_/Z _498_/A2 _498_/A3 _508_/B1 VPWR VPWR VGND VGND gf180mcu_fd_sc_mcu7t5v0__nand3_1
X_421_ _395_/Z _420_/Z _526_/B2 VPWR VPWR VGND VGND gf180mcu_fd_sc_mcu7t5v0__nor2_1
X_619_ _619_/D _619_/RN _626_/CLK _619_/Q VPWR VPWR VGND VGND gf180mcu_fd_sc_mcu7t5v0__dffrnq_2
XTAP_TAPCELL_ROW_1_53 VPWR VGND gf180mcu_fd_sc_mcu7t5v0__filltie
X_352_ _340_/Z _533_/A2 _504_/B1 VPWR VPWR VGND VGND gf180mcu_fd_sc_mcu7t5v0__nor2_1
XFILLER_18_104 VPWR VPWR VGND VGND gf180mcu_fd_sc_mcu7t5v0__fill_1
X_335_ _331_/B _346_/B _335_/B _346_/A1 VPWR VPWR VGND VGND gf180mcu_fd_sc_mcu7t5v0__aoi21_4
XFILLER_2_247 VPWR VPWR VGND VGND gf180mcu_fd_sc_mcu7t5v0__fill_2
X_404_ _527_/A1 _332_/Z _480_/A2 _505_/C VPWR VPWR VGND VGND gf180mcu_fd_sc_mcu7t5v0__nand3_2
XPHY_EDGE_ROW_10_Right_10 VPWR VGND gf180mcu_fd_sc_mcu7t5v0__endcap
X_318_ _599_/A1 _392_/A1 _323_/C _420_/A2 VPWR VPWR VGND VGND gf180mcu_fd_sc_mcu7t5v0__oai21_4
XTAP_TAPCELL_ROW_7_74 VPWR VGND gf180mcu_fd_sc_mcu7t5v0__filltie
XTAP_TAPCELL_ROW_22_127 VPWR VGND gf180mcu_fd_sc_mcu7t5v0__filltie
XFILLER_22_72 VPWR VPWR VGND VGND gf180mcu_fd_sc_mcu7t5v0__fill_1
XFILLER_17_72 VPWR VPWR VGND VGND gf180mcu_fd_sc_mcu7t5v0__fill_2
XFILLER_17_50 VPWR VPWR VGND VGND gf180mcu_fd_sc_mcu7t5v0__fill_2
X_583_ _585_/B _598_/A3 _585_/A2 _593_/B VPWR VPWR VGND VGND gf180mcu_fd_sc_mcu7t5v0__nor3_1
XTAP_TAPCELL_ROW_4_64 VPWR VGND gf180mcu_fd_sc_mcu7t5v0__filltie
XPHY_EDGE_ROW_8_Right_8 VPWR VGND gf180mcu_fd_sc_mcu7t5v0__endcap
XFILLER_9_209 VPWR VPWR VGND VGND gf180mcu_fd_sc_mcu7t5v0__fill_1
X_566_ _566_/A1 _566_/A2 _618_/D VPWR VPWR VGND VGND gf180mcu_fd_sc_mcu7t5v0__xor2_1
XFILLER_0_197 VPWR VPWR VGND VGND gf180mcu_fd_sc_mcu7t5v0__fill_1
X_497_ _310_/Z _503_/B _497_/B _528_/B VPWR VPWR VGND VGND gf180mcu_fd_sc_mcu7t5v0__oai21_1
XTAP_TAPCELL_ROW_1_54 VPWR VGND gf180mcu_fd_sc_mcu7t5v0__filltie
X_351_ _330_/Z _388_/B _533_/A2 VPWR VPWR VGND VGND gf180mcu_fd_sc_mcu7t5v0__nand2_4
XFILLER_5_212 VPWR VPWR VGND VGND gf180mcu_fd_sc_mcu7t5v0__fill_2
X_420_ _314_/Z _420_/A2 _321_/Z _420_/Z VPWR VPWR VGND VGND gf180mcu_fd_sc_mcu7t5v0__or3_4
X_549_ _611_/Q _549_/A2 _611_/D VPWR VPWR VGND VGND gf180mcu_fd_sc_mcu7t5v0__xnor2_1
X_618_ _618_/D _619_/RN _618_/CLK _618_/Q VPWR VPWR VGND VGND gf180mcu_fd_sc_mcu7t5v0__dffrnq_2
X_334_ _330_/Z _379_/A2 _533_/C VPWR VPWR VGND VGND gf180mcu_fd_sc_mcu7t5v0__nand2_4
X_403_ _346_/B _498_/A3 _486_/A1 VPWR VPWR VGND VGND gf180mcu_fd_sc_mcu7t5v0__nor2_1
XFILLER_1_270 VPWR VPWR VGND VGND gf180mcu_fd_sc_mcu7t5v0__fill_1
X_317_ _625_/Q _599_/A1 _323_/C VPWR VPWR VGND VGND gf180mcu_fd_sc_mcu7t5v0__nand2_1
XTAP_TAPCELL_ROW_7_75 VPWR VGND gf180mcu_fd_sc_mcu7t5v0__filltie
XFILLER_11_85 VPWR VPWR VGND VGND gf180mcu_fd_sc_mcu7t5v0__fill_1
XTAP_TAPCELL_ROW_22_128 VPWR VGND gf180mcu_fd_sc_mcu7t5v0__filltie
XFILLER_20_166 VPWR VPWR VGND VGND gf180mcu_fd_sc_mcu7t5v0__fill_1
XFILLER_22_62 VPWR VPWR VGND VGND gf180mcu_fd_sc_mcu7t5v0__fill_1
XFILLER_16_247 VPWR VPWR VGND VGND gf180mcu_fd_sc_mcu7t5v0__fill_2
XFILLER_4_107 VPWR VPWR VGND VGND gf180mcu_fd_sc_mcu7t5v0__fillcap_4
X_582_ _621_/Q _622_/Q _589_/A2 _585_/A2 VPWR VPWR VGND VGND gf180mcu_fd_sc_mcu7t5v0__nor3_1
XFILLER_22_206 VPWR VPWR VGND VGND gf180mcu_fd_sc_mcu7t5v0__fill_2
XTAP_TAPCELL_ROW_4_65 VPWR VGND gf180mcu_fd_sc_mcu7t5v0__filltie
X_565_ _617_/Q _562_/Z _617_/D VPWR VPWR VGND VGND gf180mcu_fd_sc_mcu7t5v0__xor2_1
X_496_ _496_/A1 _538_/B _486_/B _496_/B2 _529_/B _518_/A2 VPWR VPWR VGND VGND gf180mcu_fd_sc_mcu7t5v0__aoi221_4
XFILLER_10_2 VPWR VPWR VGND VGND gf180mcu_fd_sc_mcu7t5v0__fill_1
XTAP_TAPCELL_ROW_1_55 VPWR VGND gf180mcu_fd_sc_mcu7t5v0__filltie
X_350_ _575_/B _621_/Q _378_/A2 _515_/B VPWR VPWR VGND VGND gf180mcu_fd_sc_mcu7t5v0__nand3_2
X_548_ _610_/Q _611_/Q _548_/Z VPWR VPWR VGND VGND gf180mcu_fd_sc_mcu7t5v0__and2_1
X_617_ _617_/D _619_/RN _618_/CLK _617_/Q VPWR VPWR VGND VGND gf180mcu_fd_sc_mcu7t5v0__dffrnq_1
X_479_ _479_/A1 _479_/A2 _479_/A3 _535_/A2 _488_/A2 VPWR VPWR VGND VGND gf180mcu_fd_sc_mcu7t5v0__nand4_1
X_402_ _464_/A2 _504_/B2 _506_/A2 VPWR VPWR VGND VGND gf180mcu_fd_sc_mcu7t5v0__nand2_1
X_333_ _333_/A1 _621_/Q _333_/Z VPWR VPWR VGND VGND gf180mcu_fd_sc_mcu7t5v0__xor2_2
XPHY_EDGE_ROW_6_Left_29 VPWR VGND gf180mcu_fd_sc_mcu7t5v0__endcap
X_316_ _316_/A1 _319_/A1 _316_/B _316_/C _392_/A1 VPWR VPWR VGND VGND gf180mcu_fd_sc_mcu7t5v0__oai211_4
XTAP_TAPCELL_ROW_7_76 VPWR VGND gf180mcu_fd_sc_mcu7t5v0__filltie
XTAP_TAPCELL_ROW_22_129 VPWR VGND gf180mcu_fd_sc_mcu7t5v0__filltie
XFILLER_22_96 VPWR VPWR VGND VGND gf180mcu_fd_sc_mcu7t5v0__fillcap_4
XFILLER_22_52 VPWR VPWR VGND VGND gf180mcu_fd_sc_mcu7t5v0__fillcap_8
XFILLER_19_212 VPWR VPWR VGND VGND gf180mcu_fd_sc_mcu7t5v0__fill_2
XFILLER_8_54 VPWR VPWR VGND VGND gf180mcu_fd_sc_mcu7t5v0__fill_1
X_581_ _581_/A1 _581_/A2 _581_/B _598_/A3 VPWR VPWR VGND VGND gf180mcu_fd_sc_mcu7t5v0__aoi21_2
XFILLER_17_52 VPWR VPWR VGND VGND gf180mcu_fd_sc_mcu7t5v0__fill_1
XTAP_TAPCELL_ROW_4_66 VPWR VGND gf180mcu_fd_sc_mcu7t5v0__filltie
XPHY_EDGE_ROW_9_Left_32 VPWR VGND gf180mcu_fd_sc_mcu7t5v0__endcap
XFILLER_21_262 VPWR VPWR VGND VGND gf180mcu_fd_sc_mcu7t5v0__fillcap_8
X_564_ _617_/Q _562_/Z _566_/A2 VPWR VPWR VGND VGND gf180mcu_fd_sc_mcu7t5v0__nand2_1
X_495_ _504_/B1 _495_/A2 _494_/Z _495_/B _512_/A1 VPWR VPWR VGND VGND gf180mcu_fd_sc_mcu7t5v0__oai31_2
X_547_ _610_/Q _603_/A1 _610_/D VPWR VPWR VGND VGND gf180mcu_fd_sc_mcu7t5v0__xnor2_1
X_616_ _616_/D _619_/RN _618_/CLK _616_/Q VPWR VPWR VGND VGND gf180mcu_fd_sc_mcu7t5v0__dffrnq_1
X_478_ _365_/Z _541_/A3 _478_/B _535_/A2 VPWR VPWR VGND VGND gf180mcu_fd_sc_mcu7t5v0__oai21_1
XPHY_EDGE_ROW_22_Left_45 VPWR VGND gf180mcu_fd_sc_mcu7t5v0__endcap
XFILLER_18_107 VPWR VPWR VGND VGND gf180mcu_fd_sc_mcu7t5v0__fill_2
X_401_ _314_/Z _321_/Z _392_/Z _401_/ZN VPWR VPWR VGND VGND gf180mcu_fd_sc_mcu7t5v0__nor3_2
X_332_ _333_/A1 _581_/A1 _332_/Z VPWR VPWR VGND VGND gf180mcu_fd_sc_mcu7t5v0__xor2_2
XTAP_TAPCELL_ROW_16_105 VPWR VGND gf180mcu_fd_sc_mcu7t5v0__filltie
X_315_ _331_/B _623_/Q _316_/C VPWR VPWR VGND VGND gf180mcu_fd_sc_mcu7t5v0__nand2_1
XFILLER_0_2 VPWR VPWR VGND VGND gf180mcu_fd_sc_mcu7t5v0__fill_2
XFILLER_16_249 VPWR VPWR VGND VGND gf180mcu_fd_sc_mcu7t5v0__fill_1
X_580_ _622_/Q _603_/A1 _588_/B VPWR VPWR VGND VGND gf180mcu_fd_sc_mcu7t5v0__nand2_1
X_563_ _616_/Q _563_/A2 _616_/D VPWR VPWR VGND VGND gf180mcu_fd_sc_mcu7t5v0__xor2_1
XPHY_EDGE_ROW_17_Right_17 VPWR VGND gf180mcu_fd_sc_mcu7t5v0__endcap
X_494_ _541_/A1 _501_/A3 _494_/Z VPWR VPWR VGND VGND gf180mcu_fd_sc_mcu7t5v0__or2_1
XTAP_TAPCELL_ROW_14_98 VPWR VGND gf180mcu_fd_sc_mcu7t5v0__filltie
X_546_ _610_/Q _626_/D _626_/Q _549_/A2 VPWR VPWR VGND VGND gf180mcu_fd_sc_mcu7t5v0__nand3_1
X_615_ _615_/D _619_/RN _618_/CLK _615_/Q VPWR VPWR VGND VGND gf180mcu_fd_sc_mcu7t5v0__dffrnq_1
X_477_ _477_/I _541_/A3 VPWR VPWR VGND VGND gf180mcu_fd_sc_mcu7t5v0__clkinv_1
X_400_ _314_/Z _392_/Z _504_/B2 VPWR VPWR VGND VGND gf180mcu_fd_sc_mcu7t5v0__nor2_1
X_331_ _335_/B _301_/I _576_/B _331_/B _333_/A1 VPWR VPWR VGND VGND gf180mcu_fd_sc_mcu7t5v0__oai31_2
X_529_ _529_/A1 _538_/A3 _529_/B _537_/A2 VPWR VPWR VGND VGND gf180mcu_fd_sc_mcu7t5v0__aoi21_1
XTAP_TAPCELL_ROW_11_88 VPWR VGND gf180mcu_fd_sc_mcu7t5v0__filltie
XTAP_TAPCELL_ROW_16_106 VPWR VGND gf180mcu_fd_sc_mcu7t5v0__filltie
X_314_ _623_/Q _314_/A2 _314_/Z VPWR VPWR VGND VGND gf180mcu_fd_sc_mcu7t5v0__xor2_2
XFILLER_19_269 VPWR VPWR VGND VGND gf180mcu_fd_sc_mcu7t5v0__fill_2
X_562_ _616_/Q _563_/A2 _562_/Z VPWR VPWR VGND VGND gf180mcu_fd_sc_mcu7t5v0__and2_1
X_493_ _500_/B _493_/A2 _503_/A1 _501_/A3 VPWR VPWR VGND VGND gf180mcu_fd_sc_mcu7t5v0__nand3_1
XTAP_TAPCELL_ROW_14_99 VPWR VGND gf180mcu_fd_sc_mcu7t5v0__filltie
X_614_ _614_/D _619_/RN _618_/CLK _614_/Q VPWR VPWR VGND VGND gf180mcu_fd_sc_mcu7t5v0__dffrnq_1
X_545_ _626_/D _626_/Q _545_/ZN VPWR VPWR VGND VGND gf180mcu_fd_sc_mcu7t5v0__nand2_1
X_476_ _533_/A2 _476_/I1 _476_/S _477_/I VPWR VPWR VGND VGND gf180mcu_fd_sc_mcu7t5v0__mux2_2
Xrebuffer50 _439_/A1 _538_/B VPWR VPWR VGND VGND gf180mcu_fd_sc_mcu7t5v0__buf_8
X_330_ _330_/A1 _575_/B _330_/Z VPWR VPWR VGND VGND gf180mcu_fd_sc_mcu7t5v0__xor2_4
X_459_ _473_/A1 _459_/A2 _538_/B _490_/A1 VPWR VPWR VGND VGND gf180mcu_fd_sc_mcu7t5v0__oai21_2
X_528_ _528_/A1 _529_/A1 _528_/B _528_/C _536_/A2 VPWR VPWR VGND VGND gf180mcu_fd_sc_mcu7t5v0__aoi211_2
XTAP_TAPCELL_ROW_11_89 VPWR VGND gf180mcu_fd_sc_mcu7t5v0__filltie
XTAP_TAPCELL_ROW_16_107 VPWR VGND gf180mcu_fd_sc_mcu7t5v0__filltie
X_313_ _623_/Q _314_/A2 _327_/A1 VPWR VPWR VGND VGND gf180mcu_fd_sc_mcu7t5v0__xnor2_2
XFILLER_19_2 VPWR VPWR VGND VGND gf180mcu_fd_sc_mcu7t5v0__fill_2
XFILLER_18_270 VPWR VPWR VGND VGND gf180mcu_fd_sc_mcu7t5v0__fill_1
XFILLER_17_33 VPWR VPWR VGND VGND gf180mcu_fd_sc_mcu7t5v0__fill_2
XPHY_EDGE_ROW_3_Right_3 VPWR VGND gf180mcu_fd_sc_mcu7t5v0__endcap
X_561_ _569_/A1 _569_/A2 _561_/B _563_/A2 VPWR VPWR VGND VGND gf180mcu_fd_sc_mcu7t5v0__aoi21_1
X_492_ _492_/A1 _386_/B _504_/C VPWR VPWR VGND VGND gf180mcu_fd_sc_mcu7t5v0__nor2_1
Xclkbuf_1_1__f_clk clkbuf_0_clk/Z _618_/CLK VPWR VPWR VGND VGND gf180mcu_fd_sc_mcu7t5v0__clkbuf_16
X_613_ _613_/D _619_/RN _618_/CLK _613_/Q VPWR VPWR VGND VGND gf180mcu_fd_sc_mcu7t5v0__dffrnq_1
X_544_ _544_/A1 _544_/A2 B[4] VPWR VPWR VGND VGND gf180mcu_fd_sc_mcu7t5v0__nand2_2
X_475_ _485_/C _475_/A2 _519_/A4 VPWR VPWR VGND VGND gf180mcu_fd_sc_mcu7t5v0__nand2_1
Xwire4 wire4/I T[6] VPWR VPWR VGND VGND gf180mcu_fd_sc_mcu7t5v0__buf_8
XTAP_TAPCELL_ROW_19_116 VPWR VGND gf180mcu_fd_sc_mcu7t5v0__filltie
X_389_ _369_/B _390_/B1 _529_/B VPWR VPWR VGND VGND gf180mcu_fd_sc_mcu7t5v0__nor2_1
X_527_ _527_/A1 _527_/A2 _420_/Z _527_/B1 _377_/B _528_/C VPWR VPWR VGND VGND gf180mcu_fd_sc_mcu7t5v0__oai32_4
X_458_ _310_/Z _509_/A2 _395_/Z _459_/A2 VPWR VPWR VGND VGND gf180mcu_fd_sc_mcu7t5v0__nand3_1
XTAP_TAPCELL_ROW_16_108 VPWR VGND gf180mcu_fd_sc_mcu7t5v0__filltie
X_312_ _622_/Q _310_/Z _331_/B _314_/A2 VPWR VPWR VGND VGND gf180mcu_fd_sc_mcu7t5v0__oai21_1
XFILLER_11_138 VPWR VPWR VGND VGND gf180mcu_fd_sc_mcu7t5v0__fill_2
XFILLER_18_260 VPWR VPWR VGND VGND gf180mcu_fd_sc_mcu7t5v0__fill_2
XFILLER_0_70 VPWR VPWR VGND VGND gf180mcu_fd_sc_mcu7t5v0__fill_2
XPHY_EDGE_ROW_13_Left_36 VPWR VGND gf180mcu_fd_sc_mcu7t5v0__endcap
X_560_ _612_/Q _613_/Q _614_/Q _615_/Q _560_/Z VPWR VPWR VGND VGND gf180mcu_fd_sc_mcu7t5v0__or4_1
X_491_ _471_/B _491_/A2 _509_/B VPWR VPWR VGND VGND gf180mcu_fd_sc_mcu7t5v0__nand2_1
XPHY_EDGE_ROW_22_Right_22 VPWR VGND gf180mcu_fd_sc_mcu7t5v0__endcap
XPHY_EDGE_ROW_13_Right_13 VPWR VGND gf180mcu_fd_sc_mcu7t5v0__endcap
X_612_ _612_/D _626_/RN _618_/CLK _612_/Q VPWR VPWR VGND VGND gf180mcu_fd_sc_mcu7t5v0__dffrnq_1
X_543_ _543_/A1 _543_/A2 _543_/A3 _544_/A1 VPWR VPWR VGND VGND gf180mcu_fd_sc_mcu7t5v0__nor3_2
X_474_ _504_/B1 _474_/A2 _474_/B _479_/A3 VPWR VPWR VGND VGND gf180mcu_fd_sc_mcu7t5v0__oai21_1
Xwire5 wire5/I T[5] VPWR VPWR VGND VGND gf180mcu_fd_sc_mcu7t5v0__buf_8
Xrebuffer52 _385_/A2 _388_/B VPWR VPWR VGND VGND gf180mcu_fd_sc_mcu7t5v0__buf_8
XTAP_TAPCELL_ROW_19_117 VPWR VGND gf180mcu_fd_sc_mcu7t5v0__filltie
X_526_ _530_/B _528_/A1 _526_/A3 _473_/B _526_/B2 wire8/I VPWR VPWR VGND VGND gf180mcu_fd_sc_mcu7t5v0__oai32_4
X_457_ _493_/A2 _386_/B _473_/A1 VPWR VPWR VGND VGND gf180mcu_fd_sc_mcu7t5v0__nand2_1
X_388_ _364_/B _340_/Z _388_/B _390_/B1 VPWR VPWR VGND VGND gf180mcu_fd_sc_mcu7t5v0__oai21_1
X_311_ _331_/B _622_/Q _316_/B VPWR VPWR VGND VGND gf180mcu_fd_sc_mcu7t5v0__nand2_1
XPHY_EDGE_ROW_1_Left_24 VPWR VGND gf180mcu_fd_sc_mcu7t5v0__endcap
X_509_ _377_/B _509_/A2 _509_/B _510_/C VPWR VPWR VGND VGND gf180mcu_fd_sc_mcu7t5v0__oai21_1
XTAP_TAPCELL_ROW_21_123 VPWR VGND gf180mcu_fd_sc_mcu7t5v0__filltie
XFILLER_8_37 VPWR VPWR VGND VGND gf180mcu_fd_sc_mcu7t5v0__fill_1
XTAP_TAPCELL_ROW_8_80 VPWR VGND gf180mcu_fd_sc_mcu7t5v0__filltie
X_490_ _490_/A1 _490_/A2 _490_/A3 _490_/A4 B[0] VPWR VPWR VGND VGND gf180mcu_fd_sc_mcu7t5v0__nand4_4
XFILLER_8_205 VPWR VPWR VGND VGND gf180mcu_fd_sc_mcu7t5v0__fill_1
XFILLER_5_16 VPWR VPWR VGND VGND gf180mcu_fd_sc_mcu7t5v0__fill_1
X_611_ _611_/D _626_/RN _618_/CLK _611_/Q VPWR VPWR VGND VGND gf180mcu_fd_sc_mcu7t5v0__dffrnq_1
X_542_ _542_/A1 _542_/A2 _542_/A3 _542_/A4 _543_/A2 VPWR VPWR VGND VGND gf180mcu_fd_sc_mcu7t5v0__nand4_1
X_473_ _473_/A1 _473_/A2 _473_/B _479_/A2 VPWR VPWR VGND VGND gf180mcu_fd_sc_mcu7t5v0__oai21_1
XFILLER_6_70 VPWR VPWR VGND VGND gf180mcu_fd_sc_mcu7t5v0__fill_2
XTAP_TAPCELL_ROW_19_118 VPWR VGND gf180mcu_fd_sc_mcu7t5v0__filltie
Xrebuffer53 _385_/A2 _359_/A2 VPWR VPWR VGND VGND gf180mcu_fd_sc_mcu7t5v0__buf_8
X_456_ _456_/A1 _456_/A2 _456_/A3 wire4/I VPWR VPWR VGND VGND gf180mcu_fd_sc_mcu7t5v0__nor3_4
X_387_ _493_/A2 _505_/B _386_/B _387_/Z VPWR VPWR VGND VGND gf180mcu_fd_sc_mcu7t5v0__and3_2
X_525_ _525_/A1 _525_/A2 _525_/A3 _525_/A4 B[2] VPWR VPWR VGND VGND gf180mcu_fd_sc_mcu7t5v0__or4_4
X_310_ _335_/B _301_/I _576_/B _621_/Q _310_/Z VPWR VPWR VGND VGND gf180mcu_fd_sc_mcu7t5v0__or4_4
XFILLER_14_104 VPWR VPWR VGND VGND gf180mcu_fd_sc_mcu7t5v0__fill_1
XFILLER_20_107 VPWR VPWR VGND VGND gf180mcu_fd_sc_mcu7t5v0__fill_1
X_439_ _439_/A1 _439_/A2 _486_/B _444_/A2 _440_/A4 VPWR VPWR VGND VGND gf180mcu_fd_sc_mcu7t5v0__aoi22_1
X_508_ _508_/A1 _519_/A4 _508_/B1 _529_/A1 _508_/C1 _520_/B2 _511_/A3 VPWR VPWR VGND
+ VGND gf180mcu_fd_sc_mcu7t5v0__aoi222_2
XFILLER_22_36 VPWR VPWR VGND VGND gf180mcu_fd_sc_mcu7t5v0__fillcap_16
XTAP_TAPCELL_ROW_21_124 VPWR VGND gf180mcu_fd_sc_mcu7t5v0__filltie
XFILLER_6_133 VPWR VPWR VGND VGND gf180mcu_fd_sc_mcu7t5v0__fill_2
XTAP_TAPCELL_ROW_12_91 VPWR VGND gf180mcu_fd_sc_mcu7t5v0__filltie
XFILLER_18_262 VPWR VPWR VGND VGND gf180mcu_fd_sc_mcu7t5v0__fill_1
XFILLER_21_246 VPWR VPWR VGND VGND gf180mcu_fd_sc_mcu7t5v0__fillcap_16
XPHY_EDGE_ROW_7_Right_7 VPWR VGND gf180mcu_fd_sc_mcu7t5v0__endcap
X_610_ _610_/D _626_/RN _626_/CLK _610_/Q VPWR VPWR VGND VGND gf180mcu_fd_sc_mcu7t5v0__dffrnq_1
X_541_ _541_/A1 _541_/A2 _541_/A3 _541_/B _542_/A4 VPWR VPWR VGND VGND gf180mcu_fd_sc_mcu7t5v0__oai31_1
X_472_ _515_/B _498_/A3 _515_/C _473_/A2 VPWR VPWR VGND VGND gf180mcu_fd_sc_mcu7t5v0__nand3_1
Xrebuffer54 _364_/B _394_/A1 VPWR VPWR VGND VGND gf180mcu_fd_sc_mcu7t5v0__buf_8
X_524_ _524_/A1 _524_/A2 _524_/A3 _525_/A3 VPWR VPWR VGND VGND gf180mcu_fd_sc_mcu7t5v0__nand3_1
X_455_ _430_/I _456_/A2 _456_/A3 wire5/I VPWR VPWR VGND VGND gf180mcu_fd_sc_mcu7t5v0__nor3_4
X_386_ _386_/A1 _505_/B _386_/B _530_/B VPWR VPWR VGND VGND gf180mcu_fd_sc_mcu7t5v0__oai21_4
XFILLER_11_38 VPWR VPWR VGND VGND gf180mcu_fd_sc_mcu7t5v0__fill_1
Xwire12 _501_/B _418_/B VPWR VPWR VGND VGND gf180mcu_fd_sc_mcu7t5v0__buf_4
X_369_ _369_/A1 _369_/A2 _369_/B _534_/B VPWR VPWR VGND VGND gf180mcu_fd_sc_mcu7t5v0__aoi21_2
X_438_ _445_/A1 _439_/A1 _444_/A2 _418_/B _440_/A3 VPWR VPWR VGND VGND gf180mcu_fd_sc_mcu7t5v0__aoi22_1
X_507_ _523_/A2 _507_/A2 _528_/B _507_/C _512_/A3 VPWR VPWR VGND VGND gf180mcu_fd_sc_mcu7t5v0__aoi211_2
XTAP_TAPCELL_ROW_21_125 VPWR VGND gf180mcu_fd_sc_mcu7t5v0__filltie
XTAP_TAPCELL_ROW_12_92 VPWR VGND gf180mcu_fd_sc_mcu7t5v0__filltie
XFILLER_18_252 VPWR VPWR VGND VGND gf180mcu_fd_sc_mcu7t5v0__fillcap_8
XFILLER_12_269 VPWR VPWR VGND VGND gf180mcu_fd_sc_mcu7t5v0__fill_2
X_471_ _501_/A2 _471_/A2 _471_/B _479_/A1 VPWR VPWR VGND VGND gf180mcu_fd_sc_mcu7t5v0__oai21_1
X_540_ _540_/A1 _540_/A2 _544_/A2 VPWR VPWR VGND VGND gf180mcu_fd_sc_mcu7t5v0__nor2_1
Xwire8 wire8/I wire8/Z VPWR VPWR VGND VGND gf180mcu_fd_sc_mcu7t5v0__clkbuf_1
Xrebuffer55 _444_/B _529_/A1 VPWR VPWR VGND VGND gf180mcu_fd_sc_mcu7t5v0__buf_8
X_523_ _541_/A1 _523_/A2 _523_/B1 _529_/A1 _524_/A1 VPWR VPWR VGND VGND gf180mcu_fd_sc_mcu7t5v0__aoi22_1
X_454_ _448_/I _454_/A2 T[4] VPWR VPWR VGND VGND gf180mcu_fd_sc_mcu7t5v0__nor2_4
X_385_ _394_/A1 _385_/A2 _480_/A2 _386_/B VPWR VPWR VGND VGND gf180mcu_fd_sc_mcu7t5v0__nand3_4
X_437_ _444_/A1 _418_/B _539_/C VPWR VPWR VGND VGND gf180mcu_fd_sc_mcu7t5v0__nand2_1
X_299_ _331_/B _319_/A1 VPWR VPWR VGND VGND gf180mcu_fd_sc_mcu7t5v0__clkinv_1
X_368_ _541_/A2 _532_/A1 _365_/Z _369_/A2 VPWR VPWR VGND VGND gf180mcu_fd_sc_mcu7t5v0__nor3_2
X_506_ _500_/B _506_/A2 _506_/B _506_/C _507_/C VPWR VPWR VGND VGND gf180mcu_fd_sc_mcu7t5v0__oai211_1
XPHY_EDGE_ROW_5_Left_28 VPWR VGND gf180mcu_fd_sc_mcu7t5v0__endcap
XTAP_TAPCELL_ROW_12_93 VPWR VGND gf180mcu_fd_sc_mcu7t5v0__filltie
XFILLER_6_135 VPWR VPWR VGND VGND gf180mcu_fd_sc_mcu7t5v0__fill_1
XFILLER_3_138 VPWR VPWR VGND VGND gf180mcu_fd_sc_mcu7t5v0__fill_2
XFILLER_2_193 VPWR VPWR VGND VGND gf180mcu_fd_sc_mcu7t5v0__fillcap_4
XFILLER_9_72 VPWR VPWR VGND VGND gf180mcu_fd_sc_mcu7t5v0__fill_1
XPHY_EDGE_ROW_8_Left_31 VPWR VGND gf180mcu_fd_sc_mcu7t5v0__endcap
XFILLER_22_2 VPWR VPWR VGND VGND gf180mcu_fd_sc_mcu7t5v0__fillcap_32
X_599_ _599_/A1 _599_/A2 _599_/Z VPWR VPWR VGND VGND gf180mcu_fd_sc_mcu7t5v0__xor2_1
X_470_ _483_/B _476_/I1 _505_/C _471_/A2 VPWR VPWR VGND VGND gf180mcu_fd_sc_mcu7t5v0__nand3_1
Xwire9 wire9/I wire9/Z VPWR VPWR VGND VGND gf180mcu_fd_sc_mcu7t5v0__clkbuf_1
Xrebuffer56 _499_/B _505_/B VPWR VPWR VGND VGND gf180mcu_fd_sc_mcu7t5v0__buf_8
X_522_ _515_/C _395_/Z _523_/B1 VPWR VPWR VGND VGND gf180mcu_fd_sc_mcu7t5v0__nand2_1
X_453_ _456_/A2 _456_/A1 _453_/A3 T[3] VPWR VPWR VGND VGND gf180mcu_fd_sc_mcu7t5v0__and3_4
X_384_ _338_/Z _476_/I1 _474_/A2 VPWR VPWR VGND VGND gf180mcu_fd_sc_mcu7t5v0__nor2_1
XFILLER_14_107 VPWR VPWR VGND VGND gf180mcu_fd_sc_mcu7t5v0__fill_1
XPHY_EDGE_ROW_21_Left_44 VPWR VGND gf180mcu_fd_sc_mcu7t5v0__endcap
XTAP_TAPCELL_ROW_15_102 VPWR VGND gf180mcu_fd_sc_mcu7t5v0__filltie
X_436_ _436_/A1 _432_/Z _531_/A1 _436_/A4 _447_/A2 VPWR VPWR VGND VGND gf180mcu_fd_sc_mcu7t5v0__nand4_2
X_367_ _498_/A3 _500_/B _491_/A2 VPWR VPWR VGND VGND gf180mcu_fd_sc_mcu7t5v0__nand2_1
X_505_ _527_/A1 _505_/A2 _505_/B _505_/C _508_/C1 VPWR VPWR VGND VGND gf180mcu_fd_sc_mcu7t5v0__oai211_1
XTAP_TAPCELL_ROW_12_94 VPWR VGND gf180mcu_fd_sc_mcu7t5v0__filltie
X_419_ _420_/A2 _314_/Z _321_/Z _523_/A2 VPWR VPWR VGND VGND gf180mcu_fd_sc_mcu7t5v0__nor3_4
XFILLER_15_2 VPWR VPWR VGND VGND gf180mcu_fd_sc_mcu7t5v0__fill_2
XFILLER_4_201 VPWR VPWR VGND VGND gf180mcu_fd_sc_mcu7t5v0__fill_1
XFILLER_4_267 VPWR VPWR VGND VGND gf180mcu_fd_sc_mcu7t5v0__fillcap_4
X_598_ _623_/Q _624_/Q _598_/A3 _606_/A3 VPWR VPWR VGND VGND gf180mcu_fd_sc_mcu7t5v0__nand3_1
Xrebuffer46 _442_/A2 _456_/A2 VPWR VPWR VGND VGND gf180mcu_fd_sc_mcu7t5v0__buf_8
X_383_ _386_/A1 _499_/B _532_/B2 VPWR VPWR VGND VGND gf180mcu_fd_sc_mcu7t5v0__nor2_1
X_452_ _456_/A1 _452_/A2 T[2] VPWR VPWR VGND VGND gf180mcu_fd_sc_mcu7t5v0__nor2_4
X_521_ _532_/A1 _478_/B _523_/A2 _521_/B2 _524_/A2 VPWR VPWR VGND VGND gf180mcu_fd_sc_mcu7t5v0__aoi22_2
XTAP_TAPCELL_ROW_15_103 VPWR VGND gf180mcu_fd_sc_mcu7t5v0__filltie
X_435_ _521_/B2 _526_/A3 _486_/B _436_/A4 VPWR VPWR VGND VGND gf180mcu_fd_sc_mcu7t5v0__oai21_1
X_504_ _504_/A1 _504_/A2 _504_/B1 _504_/B2 _504_/C _506_/C VPWR VPWR VGND VGND gf180mcu_fd_sc_mcu7t5v0__aoi221_1
X_366_ _576_/B _378_/A2 _379_/A2 _500_/B VPWR VPWR VGND VGND gf180mcu_fd_sc_mcu7t5v0__nand3_2
Xwire37 wire38/Z wire37/Z VPWR VPWR VGND VGND gf180mcu_fd_sc_mcu7t5v0__buf_4
XFILLER_10_199 VPWR VPWR VGND VGND gf180mcu_fd_sc_mcu7t5v0__fill_2
XFILLER_17_29 VPWR VPWR VGND VGND gf180mcu_fd_sc_mcu7t5v0__fillcap_4
X_349_ _346_/B _394_/A1 _379_/A2 _338_/Z _527_/B1 VPWR VPWR VGND VGND gf180mcu_fd_sc_mcu7t5v0__nand4_4
X_418_ _439_/A2 _538_/A3 _418_/B _440_/A1 VPWR VPWR VGND VGND gf180mcu_fd_sc_mcu7t5v0__oai21_1
XFILLER_2_173 VPWR VPWR VGND VGND gf180mcu_fd_sc_mcu7t5v0__fill_2
XFILLER_0_98 VPWR VPWR VGND VGND gf180mcu_fd_sc_mcu7t5v0__fillcap_4
X_597_ _592_/Z _605_/A2 _597_/B _601_/A1 VPWR VPWR VGND VGND gf180mcu_fd_sc_mcu7t5v0__oai21_1
Xrebuffer47 _309_/A4 _335_/B VPWR VPWR VGND VGND gf180mcu_fd_sc_mcu7t5v0__buf_8
Xrebuffer58 _440_/ZN _450_/A1 VPWR VPWR VGND VGND gf180mcu_fd_sc_mcu7t5v0__clkbuf_8
X_520_ _520_/A1 _541_/A3 _494_/Z _520_/B2 _474_/B _519_/Z _524_/A3 VPWR VPWR VGND
+ VGND gf180mcu_fd_sc_mcu7t5v0__aoi222_2
XTAP_TAPCELL_ROW_18_112 VPWR VGND gf180mcu_fd_sc_mcu7t5v0__filltie
X_451_ _452_/A2 _430_/I T[1] VPWR VPWR VGND VGND gf180mcu_fd_sc_mcu7t5v0__nor2_4
X_382_ _476_/S _483_/A2 _503_/A1 VPWR VPWR VGND VGND gf180mcu_fd_sc_mcu7t5v0__nand2_1
X_434_ _526_/A3 _486_/B _535_/A1 VPWR VPWR VGND VGND gf180mcu_fd_sc_mcu7t5v0__nand2_1
XTAP_TAPCELL_ROW_15_104 VPWR VGND gf180mcu_fd_sc_mcu7t5v0__filltie
X_503_ _503_/A1 _503_/A2 _503_/B _510_/B VPWR VPWR VGND VGND gf180mcu_fd_sc_mcu7t5v0__aoi21_1
X_365_ _576_/B _378_/A2 _379_/A2 _365_/Z VPWR VPWR VGND VGND gf180mcu_fd_sc_mcu7t5v0__and3_1
Xwire38 wire38/I wire38/Z VPWR VPWR VGND VGND gf180mcu_fd_sc_mcu7t5v0__buf_4
XPHY_EDGE_ROW_16_Right_16 VPWR VGND gf180mcu_fd_sc_mcu7t5v0__endcap
X_417_ _439_/A2 _418_/B _537_/A1 VPWR VPWR VGND VGND gf180mcu_fd_sc_mcu7t5v0__nand2_1
X_348_ _379_/A1 _359_/A2 _505_/A2 _541_/A1 VPWR VPWR VGND VGND gf180mcu_fd_sc_mcu7t5v0__nor3_4
XFILLER_5_160 VPWR VPWR VGND VGND gf180mcu_fd_sc_mcu7t5v0__fill_1
XFILLER_15_226 VPWR VPWR VGND VGND gf180mcu_fd_sc_mcu7t5v0__fill_2
XFILLER_15_4 VPWR VPWR VGND VGND gf180mcu_fd_sc_mcu7t5v0__fill_1
XPHY_EDGE_ROW_2_Right_2 VPWR VGND gf180mcu_fd_sc_mcu7t5v0__endcap
X_596_ _603_/A1 _596_/A2 _596_/B _623_/D VPWR VPWR VGND VGND gf180mcu_fd_sc_mcu7t5v0__oai21_1
XFILLER_4_247 VPWR VPWR VGND VGND gf180mcu_fd_sc_mcu7t5v0__fill_2
XFILLER_20_2 VPWR VPWR VGND VGND gf180mcu_fd_sc_mcu7t5v0__fillcap_8
Xrebuffer48 _309_/A2 _301_/I VPWR VPWR VGND VGND gf180mcu_fd_sc_mcu7t5v0__buf_8
X_450_ _450_/A1 _450_/A2 _452_/A2 VPWR VPWR VGND VGND gf180mcu_fd_sc_mcu7t5v0__nand2_2
X_381_ _385_/A2 _364_/B _301_/I _499_/B VPWR VPWR VGND VGND gf180mcu_fd_sc_mcu7t5v0__nand3_4
XTAP_TAPCELL_ROW_18_113 VPWR VGND gf180mcu_fd_sc_mcu7t5v0__filltie
XFILLER_16_162 VPWR VPWR VGND VGND gf180mcu_fd_sc_mcu7t5v0__fill_2
X_579_ _603_/A1 _577_/Z _579_/B _621_/D VPWR VPWR VGND VGND gf180mcu_fd_sc_mcu7t5v0__oai21_1
X_433_ _531_/A1 _432_/Z _543_/A3 VPWR VPWR VGND VGND gf180mcu_fd_sc_mcu7t5v0__nand2_1
X_502_ _321_/Z _527_/A1 _332_/Z _338_/Z _503_/A2 VPWR VPWR VGND VGND gf180mcu_fd_sc_mcu7t5v0__nand4_1
X_364_ _527_/A2 _500_/A2 _364_/B _364_/C _532_/A1 VPWR VPWR VGND VGND gf180mcu_fd_sc_mcu7t5v0__aoi211_4
XFILLER_8_191 VPWR VPWR VGND VGND gf180mcu_fd_sc_mcu7t5v0__fill_1
XFILLER_18_268 VPWR VPWR VGND VGND gf180mcu_fd_sc_mcu7t5v0__fill_2
X_416_ _439_/A1 _538_/A3 _418_/B _444_/A2 _428_/A1 VPWR VPWR VGND VGND gf180mcu_fd_sc_mcu7t5v0__aoi22_2
X_347_ _364_/C _527_/A2 _412_/A1 VPWR VPWR VGND VGND gf180mcu_fd_sc_mcu7t5v0__nor2_2
XFILLER_20_263 VPWR VPWR VGND VGND gf180mcu_fd_sc_mcu7t5v0__fillcap_8
XFILLER_7_212 VPWR VPWR VGND VGND gf180mcu_fd_sc_mcu7t5v0__fillcap_4
XPHY_EDGE_ROW_12_Left_35 VPWR VGND gf180mcu_fd_sc_mcu7t5v0__endcap
XFILLER_20_31 VPWR VPWR VGND VGND gf180mcu_fd_sc_mcu7t5v0__fillcap_4
X_595_ _623_/Q _603_/A1 _596_/B VPWR VPWR VGND VGND gf180mcu_fd_sc_mcu7t5v0__nand2_1
Xrebuffer49 _620_/Q _576_/B VPWR VPWR VGND VGND gf180mcu_fd_sc_mcu7t5v0__buf_8
XFILLER_13_2 VPWR VPWR VGND VGND gf180mcu_fd_sc_mcu7t5v0__fill_1
X_380_ _527_/A1 _364_/C _476_/I1 VPWR VPWR VGND VGND gf180mcu_fd_sc_mcu7t5v0__nand2_1
XFILLER_15_53 VPWR VPWR VGND VGND gf180mcu_fd_sc_mcu7t5v0__fill_2
XTAP_TAPCELL_ROW_2_56 VPWR VGND gf180mcu_fd_sc_mcu7t5v0__filltie
XTAP_TAPCELL_ROW_18_114 VPWR VGND gf180mcu_fd_sc_mcu7t5v0__filltie
X_578_ _621_/Q _603_/A1 _579_/B VPWR VPWR VGND VGND gf180mcu_fd_sc_mcu7t5v0__nand2_1
.ends
