* NGSPICE file created from tt_um_transmit_5_3.ext - technology: gf180mcuD

* Black-box entry subcircuit for gf180mcu_fd_sc_mcu7t5v0__fill_1 abstract view
.subckt gf180mcu_fd_sc_mcu7t5v0__fill_1 VDD VNW VPW VSS
.ends

* Black-box entry subcircuit for gf180mcu_fd_sc_mcu7t5v0__nand2_2 abstract view
.subckt gf180mcu_fd_sc_mcu7t5v0__nand2_2 A1 A2 ZN VDD VNW VPW VSS
.ends

* Black-box entry subcircuit for gf180mcu_fd_sc_mcu7t5v0__or4_1 abstract view
.subckt gf180mcu_fd_sc_mcu7t5v0__or4_1 A1 A2 A3 A4 Z VDD VNW VPW VSS
.ends

* Black-box entry subcircuit for gf180mcu_fd_sc_mcu7t5v0__fill_2 abstract view
.subckt gf180mcu_fd_sc_mcu7t5v0__fill_2 VDD VNW VPW VSS
.ends

* Black-box entry subcircuit for gf180mcu_fd_sc_mcu7t5v0__oai21_1 abstract view
.subckt gf180mcu_fd_sc_mcu7t5v0__oai21_1 A1 A2 B ZN VDD VNW VPW VSS
.ends

* Black-box entry subcircuit for gf180mcu_fd_sc_mcu7t5v0__nand2_1 abstract view
.subckt gf180mcu_fd_sc_mcu7t5v0__nand2_1 A1 A2 ZN VDD VNW VPW VSS
.ends

* Black-box entry subcircuit for gf180mcu_fd_sc_mcu7t5v0__nor3_4 abstract view
.subckt gf180mcu_fd_sc_mcu7t5v0__nor3_4 A1 A2 A3 ZN VDD VNW VPW VSS
.ends

* Black-box entry subcircuit for gf180mcu_fd_sc_mcu7t5v0__fillcap_64 abstract view
.subckt gf180mcu_fd_sc_mcu7t5v0__fillcap_64 VDD VNW VPW VSS
.ends

* Black-box entry subcircuit for gf180mcu_fd_sc_mcu7t5v0__fillcap_4 abstract view
.subckt gf180mcu_fd_sc_mcu7t5v0__fillcap_4 VDD VNW VPW VSS
.ends

* Black-box entry subcircuit for gf180mcu_fd_sc_mcu7t5v0__nor2_4 abstract view
.subckt gf180mcu_fd_sc_mcu7t5v0__nor2_4 A1 A2 ZN VDD VNW VPW VSS
.ends

* Black-box entry subcircuit for gf180mcu_fd_sc_mcu7t5v0__buf_4 abstract view
.subckt gf180mcu_fd_sc_mcu7t5v0__buf_4 I Z VDD VNW VPW VSS
.ends

* Black-box entry subcircuit for gf180mcu_fd_sc_mcu7t5v0__buf_3 abstract view
.subckt gf180mcu_fd_sc_mcu7t5v0__buf_3 I Z VDD VNW VPW VSS
.ends

* Black-box entry subcircuit for gf180mcu_fd_sc_mcu7t5v0__nor2_1 abstract view
.subckt gf180mcu_fd_sc_mcu7t5v0__nor2_1 A1 A2 ZN VDD VNW VPW VSS
.ends

* Black-box entry subcircuit for gf180mcu_fd_sc_mcu7t5v0__endcap abstract view
.subckt gf180mcu_fd_sc_mcu7t5v0__endcap VDD VSS
.ends

* Black-box entry subcircuit for gf180mcu_fd_sc_mcu7t5v0__xor2_1 abstract view
.subckt gf180mcu_fd_sc_mcu7t5v0__xor2_1 A1 A2 Z VDD VNW VPW VSS
.ends

* Black-box entry subcircuit for gf180mcu_fd_sc_mcu7t5v0__dffq_1 abstract view
.subckt gf180mcu_fd_sc_mcu7t5v0__dffq_1 D CLK Q VDD VNW VPW VSS
.ends

* Black-box entry subcircuit for gf180mcu_fd_sc_mcu7t5v0__or2_2 abstract view
.subckt gf180mcu_fd_sc_mcu7t5v0__or2_2 A1 A2 Z VDD VNW VPW VSS
.ends

* Black-box entry subcircuit for gf180mcu_fd_sc_mcu7t5v0__and2_1 abstract view
.subckt gf180mcu_fd_sc_mcu7t5v0__and2_1 A1 A2 Z VDD VNW VPW VSS
.ends

* Black-box entry subcircuit for gf180mcu_fd_sc_mcu7t5v0__xnor2_2 abstract view
.subckt gf180mcu_fd_sc_mcu7t5v0__xnor2_2 A1 A2 ZN VDD VNW VPW VSS
.ends

* Black-box entry subcircuit for gf180mcu_fd_sc_mcu7t5v0__fillcap_16 abstract view
.subckt gf180mcu_fd_sc_mcu7t5v0__fillcap_16 VDD VNW VPW VSS
.ends

* Black-box entry subcircuit for gf180mcu_fd_sc_mcu7t5v0__fillcap_32 abstract view
.subckt gf180mcu_fd_sc_mcu7t5v0__fillcap_32 VDD VNW VPW VSS
.ends

* Black-box entry subcircuit for gf180mcu_fd_sc_mcu7t5v0__filltie abstract view
.subckt gf180mcu_fd_sc_mcu7t5v0__filltie VDD VSS
.ends

* Black-box entry subcircuit for gf180mcu_fd_sc_mcu7t5v0__clkbuf_1 abstract view
.subckt gf180mcu_fd_sc_mcu7t5v0__clkbuf_1 I Z VDD VNW VPW VSS
.ends

* Black-box entry subcircuit for gf180mcu_fd_sc_mcu7t5v0__xor3_1 abstract view
.subckt gf180mcu_fd_sc_mcu7t5v0__xor3_1 A1 A2 A3 Z VDD VNW VPW VSS
.ends

* Black-box entry subcircuit for gf180mcu_fd_sc_mcu7t5v0__xnor2_1 abstract view
.subckt gf180mcu_fd_sc_mcu7t5v0__xnor2_1 A1 A2 ZN VDD VNW VPW VSS
.ends

* Black-box entry subcircuit for gf180mcu_fd_sc_mcu7t5v0__buf_2 abstract view
.subckt gf180mcu_fd_sc_mcu7t5v0__buf_2 I Z VDD VNW VPW VSS
.ends

* Black-box entry subcircuit for gf180mcu_fd_sc_mcu7t5v0__fillcap_8 abstract view
.subckt gf180mcu_fd_sc_mcu7t5v0__fillcap_8 VDD VNW VPW VSS
.ends

* Black-box entry subcircuit for gf180mcu_fd_sc_mcu7t5v0__dffrnq_2 abstract view
.subckt gf180mcu_fd_sc_mcu7t5v0__dffrnq_2 D RN CLK Q VDD VNW VPW VSS
.ends

* Black-box entry subcircuit for gf180mcu_fd_sc_mcu7t5v0__nand4_4 abstract view
.subckt gf180mcu_fd_sc_mcu7t5v0__nand4_4 A1 A2 A3 A4 ZN VDD VNW VPW VSS
.ends

* Black-box entry subcircuit for gf180mcu_fd_sc_mcu7t5v0__nand3_4 abstract view
.subckt gf180mcu_fd_sc_mcu7t5v0__nand3_4 A1 A2 A3 ZN VDD VNW VPW VSS
.ends

* Black-box entry subcircuit for gf180mcu_fd_sc_mcu7t5v0__aoi21_1 abstract view
.subckt gf180mcu_fd_sc_mcu7t5v0__aoi21_1 A1 A2 B ZN VDD VNW VPW VSS
.ends

* Black-box entry subcircuit for gf180mcu_fd_sc_mcu7t5v0__oai21_2 abstract view
.subckt gf180mcu_fd_sc_mcu7t5v0__oai21_2 A1 A2 B ZN VDD VNW VPW VSS
.ends

* Black-box entry subcircuit for gf180mcu_fd_sc_mcu7t5v0__xor2_2 abstract view
.subckt gf180mcu_fd_sc_mcu7t5v0__xor2_2 A1 A2 Z VDD VNW VPW VSS
.ends

* Black-box entry subcircuit for gf180mcu_fd_sc_mcu7t5v0__aoi21_2 abstract view
.subckt gf180mcu_fd_sc_mcu7t5v0__aoi21_2 A1 A2 B ZN VDD VNW VPW VSS
.ends

* Black-box entry subcircuit for gf180mcu_fd_sc_mcu7t5v0__clkinv_1 abstract view
.subckt gf180mcu_fd_sc_mcu7t5v0__clkinv_1 I ZN VDD VNW VPW VSS
.ends

* Black-box entry subcircuit for gf180mcu_fd_sc_mcu7t5v0__or2_1 abstract view
.subckt gf180mcu_fd_sc_mcu7t5v0__or2_1 A1 A2 Z VDD VNW VPW VSS
.ends

* Black-box entry subcircuit for gf180mcu_fd_sc_mcu7t5v0__and4_1 abstract view
.subckt gf180mcu_fd_sc_mcu7t5v0__and4_1 A1 A2 A3 A4 Z VDD VNW VPW VSS
.ends

* Black-box entry subcircuit for gf180mcu_fd_sc_mcu7t5v0__or4_4 abstract view
.subckt gf180mcu_fd_sc_mcu7t5v0__or4_4 A1 A2 A3 A4 Z VDD VNW VPW VSS
.ends

* Black-box entry subcircuit for gf180mcu_fd_sc_mcu7t5v0__nand3_1 abstract view
.subckt gf180mcu_fd_sc_mcu7t5v0__nand3_1 A1 A2 A3 ZN VDD VNW VPW VSS
.ends

* Black-box entry subcircuit for gf180mcu_fd_sc_mcu7t5v0__clkbuf_2 abstract view
.subckt gf180mcu_fd_sc_mcu7t5v0__clkbuf_2 I Z VDD VNW VPW VSS
.ends

* Black-box entry subcircuit for gf180mcu_fd_sc_mcu7t5v0__buf_1 abstract view
.subckt gf180mcu_fd_sc_mcu7t5v0__buf_1 I Z VDD VNW VPW VSS
.ends

* Black-box entry subcircuit for gf180mcu_fd_sc_mcu7t5v0__dffrnq_1 abstract view
.subckt gf180mcu_fd_sc_mcu7t5v0__dffrnq_1 D RN CLK Q VDD VNW VPW VSS
.ends

* Black-box entry subcircuit for gf180mcu_fd_sc_mcu7t5v0__oai31_1 abstract view
.subckt gf180mcu_fd_sc_mcu7t5v0__oai31_1 A1 A2 A3 B ZN VDD VNW VPW VSS
.ends

* Black-box entry subcircuit for gf180mcu_fd_sc_mcu7t5v0__aoi221_1 abstract view
.subckt gf180mcu_fd_sc_mcu7t5v0__aoi221_1 A1 A2 B1 B2 C ZN VDD VNW VPW VSS
.ends

* Black-box entry subcircuit for gf180mcu_fd_sc_mcu7t5v0__aoi22_1 abstract view
.subckt gf180mcu_fd_sc_mcu7t5v0__aoi22_1 A1 A2 B1 B2 ZN VDD VNW VPW VSS
.ends

* Black-box entry subcircuit for gf180mcu_fd_sc_mcu7t5v0__oai31_4 abstract view
.subckt gf180mcu_fd_sc_mcu7t5v0__oai31_4 A1 A2 A3 B ZN VDD VNW VPW VSS
.ends

* Black-box entry subcircuit for gf180mcu_fd_sc_mcu7t5v0__aoi221_4 abstract view
.subckt gf180mcu_fd_sc_mcu7t5v0__aoi221_4 A1 A2 B1 B2 C ZN VDD VNW VPW VSS
.ends

* Black-box entry subcircuit for gf180mcu_fd_sc_mcu7t5v0__mux2_2 abstract view
.subckt gf180mcu_fd_sc_mcu7t5v0__mux2_2 I0 I1 S Z VDD VNW VPW VSS
.ends

* Black-box entry subcircuit for gf180mcu_fd_sc_mcu7t5v0__and3_1 abstract view
.subckt gf180mcu_fd_sc_mcu7t5v0__and3_1 A1 A2 A3 Z VDD VNW VPW VSS
.ends

* Black-box entry subcircuit for gf180mcu_fd_sc_mcu7t5v0__clkbuf_16 abstract view
.subckt gf180mcu_fd_sc_mcu7t5v0__clkbuf_16 I Z VDD VNW VPW VSS
.ends

* Black-box entry subcircuit for gf180mcu_fd_sc_mcu7t5v0__nor3_2 abstract view
.subckt gf180mcu_fd_sc_mcu7t5v0__nor3_2 A1 A2 A3 ZN VDD VNW VPW VSS
.ends

* Black-box entry subcircuit for gf180mcu_fd_sc_mcu7t5v0__nor3_1 abstract view
.subckt gf180mcu_fd_sc_mcu7t5v0__nor3_1 A1 A2 A3 ZN VDD VNW VPW VSS
.ends

* Black-box entry subcircuit for gf180mcu_fd_sc_mcu7t5v0__or3_4 abstract view
.subckt gf180mcu_fd_sc_mcu7t5v0__or3_4 A1 A2 A3 Z VDD VNW VPW VSS
.ends

* Black-box entry subcircuit for gf180mcu_fd_sc_mcu7t5v0__nor4_1 abstract view
.subckt gf180mcu_fd_sc_mcu7t5v0__nor4_1 A1 A2 A3 A4 ZN VDD VNW VPW VSS
.ends

* Black-box entry subcircuit for gf180mcu_fd_sc_mcu7t5v0__dlyb_1 abstract view
.subckt gf180mcu_fd_sc_mcu7t5v0__dlyb_1 I Z VDD VNW VPW VSS
.ends

* Black-box entry subcircuit for gf180mcu_fd_sc_mcu7t5v0__nand4_1 abstract view
.subckt gf180mcu_fd_sc_mcu7t5v0__nand4_1 A1 A2 A3 A4 ZN VDD VNW VPW VSS
.ends

* Black-box entry subcircuit for gf180mcu_fd_sc_mcu7t5v0__oai32_4 abstract view
.subckt gf180mcu_fd_sc_mcu7t5v0__oai32_4 A1 A2 A3 B1 B2 ZN VDD VNW VPW VSS
.ends

* Black-box entry subcircuit for gf180mcu_fd_sc_mcu7t5v0__aoi211_2 abstract view
.subckt gf180mcu_fd_sc_mcu7t5v0__aoi211_2 A1 A2 B C ZN VDD VNW VPW VSS
.ends

* Black-box entry subcircuit for gf180mcu_fd_sc_mcu7t5v0__oai221_4 abstract view
.subckt gf180mcu_fd_sc_mcu7t5v0__oai221_4 A1 A2 B1 B2 C ZN VDD VNW VPW VSS
.ends

* Black-box entry subcircuit for gf180mcu_fd_sc_mcu7t5v0__aoi211_4 abstract view
.subckt gf180mcu_fd_sc_mcu7t5v0__aoi211_4 A1 A2 B C ZN VDD VNW VPW VSS
.ends

* Black-box entry subcircuit for gf180mcu_fd_sc_mcu7t5v0__buf_8 abstract view
.subckt gf180mcu_fd_sc_mcu7t5v0__buf_8 I Z VDD VNW VPW VSS
.ends

* Black-box entry subcircuit for gf180mcu_fd_sc_mcu7t5v0__oai211_1 abstract view
.subckt gf180mcu_fd_sc_mcu7t5v0__oai211_1 A1 A2 B C ZN VDD VNW VPW VSS
.ends

* Black-box entry subcircuit for gf180mcu_fd_sc_mcu7t5v0__and3_4 abstract view
.subckt gf180mcu_fd_sc_mcu7t5v0__and3_4 A1 A2 A3 Z VDD VNW VPW VSS
.ends

* Black-box entry subcircuit for gf180mcu_fd_sc_mcu7t5v0__clkbuf_4 abstract view
.subckt gf180mcu_fd_sc_mcu7t5v0__clkbuf_4 I Z VDD VNW VPW VSS
.ends

* Black-box entry subcircuit for gf180mcu_fd_sc_mcu7t5v0__or3_2 abstract view
.subckt gf180mcu_fd_sc_mcu7t5v0__or3_2 A1 A2 A3 Z VDD VNW VPW VSS
.ends

* Black-box entry subcircuit for gf180mcu_fd_sc_mcu7t5v0__oai22_1 abstract view
.subckt gf180mcu_fd_sc_mcu7t5v0__oai22_1 A1 A2 B1 B2 ZN VDD VNW VPW VSS
.ends

* Black-box entry subcircuit for gf180mcu_fd_sc_mcu7t5v0__nor2_2 abstract view
.subckt gf180mcu_fd_sc_mcu7t5v0__nor2_2 A1 A2 ZN VDD VNW VPW VSS
.ends

* Black-box entry subcircuit for gf180mcu_fd_sc_mcu7t5v0__nand3_2 abstract view
.subckt gf180mcu_fd_sc_mcu7t5v0__nand3_2 A1 A2 A3 ZN VDD VNW VPW VSS
.ends

* Black-box entry subcircuit for gf180mcu_fd_sc_mcu7t5v0__and2_2 abstract view
.subckt gf180mcu_fd_sc_mcu7t5v0__and2_2 A1 A2 Z VDD VNW VPW VSS
.ends

* Black-box entry subcircuit for gf180mcu_fd_sc_mcu7t5v0__and2_4 abstract view
.subckt gf180mcu_fd_sc_mcu7t5v0__and2_4 A1 A2 Z VDD VNW VPW VSS
.ends

* Black-box entry subcircuit for gf180mcu_fd_sc_mcu7t5v0__nor4_4 abstract view
.subckt gf180mcu_fd_sc_mcu7t5v0__nor4_4 A1 A2 A3 A4 ZN VDD VNW VPW VSS
.ends

* Black-box entry subcircuit for gf180mcu_fd_sc_mcu7t5v0__aoi211_1 abstract view
.subckt gf180mcu_fd_sc_mcu7t5v0__aoi211_1 A1 A2 B C ZN VDD VNW VPW VSS
.ends

* Black-box entry subcircuit for gf180mcu_fd_sc_mcu7t5v0__oai211_4 abstract view
.subckt gf180mcu_fd_sc_mcu7t5v0__oai211_4 A1 A2 B C ZN VDD VNW VPW VSS
.ends

* Black-box entry subcircuit for gf180mcu_fd_sc_mcu7t5v0__oai211_2 abstract view
.subckt gf180mcu_fd_sc_mcu7t5v0__oai211_2 A1 A2 B C ZN VDD VNW VPW VSS
.ends

* Black-box entry subcircuit for gf180mcu_fd_sc_mcu7t5v0__inv_1 abstract view
.subckt gf180mcu_fd_sc_mcu7t5v0__inv_1 I ZN VDD VNW VPW VSS
.ends

* Black-box entry subcircuit for gf180mcu_fd_sc_mcu7t5v0__clkbuf_8 abstract view
.subckt gf180mcu_fd_sc_mcu7t5v0__clkbuf_8 I Z VDD VNW VPW VSS
.ends

* Black-box entry subcircuit for gf180mcu_fd_sc_mcu7t5v0__and3_2 abstract view
.subckt gf180mcu_fd_sc_mcu7t5v0__and3_2 A1 A2 A3 Z VDD VNW VPW VSS
.ends

* Black-box entry subcircuit for gf180mcu_fd_sc_mcu7t5v0__aoi222_1 abstract view
.subckt gf180mcu_fd_sc_mcu7t5v0__aoi222_1 A1 A2 B1 B2 C1 C2 ZN VDD VNW VPW VSS
.ends

* Black-box entry subcircuit for gf180mcu_fd_sc_mcu7t5v0__aoi22_2 abstract view
.subckt gf180mcu_fd_sc_mcu7t5v0__aoi22_2 A1 A2 B1 B2 ZN VDD VNW VPW VSS
.ends

* Black-box entry subcircuit for gf180mcu_fd_sc_mcu7t5v0__inv_2 abstract view
.subckt gf180mcu_fd_sc_mcu7t5v0__inv_2 I ZN VDD VNW VPW VSS
.ends

* Black-box entry subcircuit for gf180mcu_fd_sc_mcu7t5v0__nand2_4 abstract view
.subckt gf180mcu_fd_sc_mcu7t5v0__nand2_4 A1 A2 ZN VDD VNW VPW VSS
.ends

* Black-box entry subcircuit for gf180mcu_fd_sc_mcu7t5v0__nor4_2 abstract view
.subckt gf180mcu_fd_sc_mcu7t5v0__nor4_2 A1 A2 A3 A4 ZN VDD VNW VPW VSS
.ends

* Black-box entry subcircuit for gf180mcu_fd_sc_mcu7t5v0__nand4_2 abstract view
.subckt gf180mcu_fd_sc_mcu7t5v0__nand4_2 A1 A2 A3 A4 ZN VDD VNW VPW VSS
.ends

* Black-box entry subcircuit for gf180mcu_fd_sc_mcu7t5v0__aoi222_2 abstract view
.subckt gf180mcu_fd_sc_mcu7t5v0__aoi222_2 A1 A2 B1 B2 C1 C2 ZN VDD VNW VPW VSS
.ends

* Black-box entry subcircuit for gf180mcu_fd_sc_mcu7t5v0__or2_4 abstract view
.subckt gf180mcu_fd_sc_mcu7t5v0__or2_4 A1 A2 Z VDD VNW VPW VSS
.ends

* Black-box entry subcircuit for gf180mcu_fd_sc_mcu7t5v0__oai21_4 abstract view
.subckt gf180mcu_fd_sc_mcu7t5v0__oai21_4 A1 A2 B ZN VDD VNW VPW VSS
.ends

* Black-box entry subcircuit for gf180mcu_fd_sc_mcu7t5v0__or4_2 abstract view
.subckt gf180mcu_fd_sc_mcu7t5v0__or4_2 A1 A2 A3 A4 Z VDD VNW VPW VSS
.ends

.subckt tt_um_transmit_5_3 B[0] B[1] B[2] B[3] B[4] T[0] T[1] T[2] T[3] T[4] T[5]
+ T[6] VGND VPWR clk enable in rst_n
XFILLER_22_122 VPWR VPWR VGND VGND gf180mcu_fd_sc_mcu7t5v0__fill_1
X_363_ _584_/A2 _577_/A1 _430_/A3 VPWR VPWR VGND VGND gf180mcu_fd_sc_mcu7t5v0__nand2_2
X_501_ _501_/A1 _504_/A2 _535_/B _501_/A4 _501_/Z VPWR VPWR VGND VGND gf180mcu_fd_sc_mcu7t5v0__or4_1
XFILLER_9_137 VPWR VPWR VGND VGND gf180mcu_fd_sc_mcu7t5v0__fill_2
X_432_ _502_/B _541_/B _432_/B _433_/A2 VPWR VPWR VGND VGND gf180mcu_fd_sc_mcu7t5v0__oai21_1
X_415_ _415_/A1 _354_/B _550_/B VPWR VPWR VGND VGND gf180mcu_fd_sc_mcu7t5v0__nand2_1
X_346_ _577_/A1 _396_/A3 _430_/A2 _536_/A1 VPWR VPWR VGND VGND gf180mcu_fd_sc_mcu7t5v0__nor3_4
XFILLER_6_107 VPWR VPWR VGND VGND gf180mcu_fd_sc_mcu7t5v0__fillcap_64
XFILLER_10_103 VPWR VPWR VGND VGND gf180mcu_fd_sc_mcu7t5v0__fill_2
XFILLER_12_32 VPWR VPWR VGND VGND gf180mcu_fd_sc_mcu7t5v0__fill_2
XFILLER_23_20 VPWR VPWR VGND VGND gf180mcu_fd_sc_mcu7t5v0__fill_2
XFILLER_9_22 VPWR VPWR VGND VGND gf180mcu_fd_sc_mcu7t5v0__fill_2
XFILLER_9_44 VPWR VPWR VGND VGND gf180mcu_fd_sc_mcu7t5v0__fillcap_4
X_329_ _379_/C _379_/B _449_/A1 VPWR VPWR VGND VGND gf180mcu_fd_sc_mcu7t5v0__nor2_4
XFILLER_18_31 VPWR VPWR VGND VGND gf180mcu_fd_sc_mcu7t5v0__fillcap_4
Xload_slew41 _546_/A1 _536_/A4 VPWR VPWR VGND VGND gf180mcu_fd_sc_mcu7t5v0__buf_4
Xload_slew30 _451_/B1 _541_/B VPWR VPWR VGND VGND gf180mcu_fd_sc_mcu7t5v0__buf_3
Xload_slew52 _532_/A1 _331_/A2 VPWR VPWR VGND VGND gf180mcu_fd_sc_mcu7t5v0__buf_4
X_594_ _596_/A1 _593_/Z _619_/A2 VPWR VPWR VGND VGND gf180mcu_fd_sc_mcu7t5v0__nor2_1
XFILLER_34_197 VPWR VPWR VGND VGND gf180mcu_fd_sc_mcu7t5v0__fill_2
XFILLER_19_161 VPWR VPWR VGND VGND gf180mcu_fd_sc_mcu7t5v0__fill_2
XFILLER_6_34 VPWR VPWR VGND VGND gf180mcu_fd_sc_mcu7t5v0__fill_1
XPHY_EDGE_ROW_16_Left_59 VPWR VGND gf180mcu_fd_sc_mcu7t5v0__endcap
X_577_ _577_/A1 _574_/Z _637_/D VPWR VPWR VGND VGND gf180mcu_fd_sc_mcu7t5v0__xor2_1
X_646_ _646_/D _646_/CLK _646_/Q VPWR VPWR VGND VGND gf180mcu_fd_sc_mcu7t5v0__dffq_1
XFILLER_16_197 VPWR VPWR VGND VGND gf180mcu_fd_sc_mcu7t5v0__fill_2
XFILLER_42_30 VPWR VPWR VGND VGND gf180mcu_fd_sc_mcu7t5v0__fillcap_4
X_431_ _543_/A1 _513_/A2 _432_/B VPWR VPWR VGND VGND gf180mcu_fd_sc_mcu7t5v0__or2_2
X_362_ _339_/Z _430_/A1 _391_/A3 _520_/B2 VPWR VPWR VGND VGND gf180mcu_fd_sc_mcu7t5v0__nor3_4
X_500_ _512_/B _468_/B _500_/B _503_/A3 VPWR VPWR VGND VGND gf180mcu_fd_sc_mcu7t5v0__oai21_1
X_629_ _639_/RN _647_/Q _648_/D VPWR VPWR VGND VGND gf180mcu_fd_sc_mcu7t5v0__and2_1
XFILLER_8_171 VPWR VPWR VGND VGND gf180mcu_fd_sc_mcu7t5v0__fillcap_4
XFILLER_8_193 VPWR VPWR VGND VGND gf180mcu_fd_sc_mcu7t5v0__fillcap_4
XPHY_EDGE_ROW_19_Left_62 VPWR VGND gf180mcu_fd_sc_mcu7t5v0__endcap
XFILLER_10_115 VPWR VPWR VGND VGND gf180mcu_fd_sc_mcu7t5v0__fillcap_4
XFILLER_10_159 VPWR VPWR VGND VGND gf180mcu_fd_sc_mcu7t5v0__fill_2
X_345_ _345_/A1 _396_/A1 _345_/ZN VPWR VPWR VGND VGND gf180mcu_fd_sc_mcu7t5v0__xnor2_2
XFILLER_5_174 VPWR VPWR VGND VGND gf180mcu_fd_sc_mcu7t5v0__fillcap_16
X_414_ _414_/A1 _333_/Z _412_/Z _414_/ZN VPWR VPWR VGND VGND gf180mcu_fd_sc_mcu7t5v0__nor3_4
XPHY_EDGE_ROW_21_Right_21 VPWR VGND gf180mcu_fd_sc_mcu7t5v0__endcap
XPHY_EDGE_ROW_4_Left_47 VPWR VGND gf180mcu_fd_sc_mcu7t5v0__endcap
XPHY_EDGE_ROW_12_Right_12 VPWR VGND gf180mcu_fd_sc_mcu7t5v0__endcap
XPHY_EDGE_ROW_30_Right_30 VPWR VGND gf180mcu_fd_sc_mcu7t5v0__endcap
X_328_ _435_/A1 _435_/A2 _476_/A1 VPWR VPWR VGND VGND gf180mcu_fd_sc_mcu7t5v0__nand2_1
XFILLER_3_2 VPWR VPWR VGND VGND gf180mcu_fd_sc_mcu7t5v0__fillcap_64
XFILLER_2_199 VPWR VPWR VGND VGND gf180mcu_fd_sc_mcu7t5v0__fill_1
XFILLER_2_177 VPWR VPWR VGND VGND gf180mcu_fd_sc_mcu7t5v0__fillcap_16
XFILLER_0_36 VPWR VPWR VGND VGND gf180mcu_fd_sc_mcu7t5v0__fillcap_32
XFILLER_36_2 VPWR VPWR VGND VGND gf180mcu_fd_sc_mcu7t5v0__fill_2
XTAP_TAPCELL_ROW_0_90 VPWR VGND gf180mcu_fd_sc_mcu7t5v0__filltie
Xload_slew53 _532_/A1 _441_/A1 VPWR VPWR VGND VGND gf180mcu_fd_sc_mcu7t5v0__clkbuf_1
Xload_slew42 _482_/A1 _507_/A1 VPWR VPWR VGND VGND gf180mcu_fd_sc_mcu7t5v0__buf_4
Xload_slew20 _543_/C1 _551_/B1 VPWR VPWR VGND VGND gf180mcu_fd_sc_mcu7t5v0__clkbuf_1
XFILLER_20_22 VPWR VPWR VGND VGND gf180mcu_fd_sc_mcu7t5v0__fill_1
XFILLER_20_33 VPWR VPWR VGND VGND gf180mcu_fd_sc_mcu7t5v0__fill_2
X_593_ _646_/Q _641_/Q _593_/A3 _593_/Z VPWR VPWR VGND VGND gf180mcu_fd_sc_mcu7t5v0__xor3_1
XPHY_EDGE_ROW_7_Left_50 VPWR VGND gf180mcu_fd_sc_mcu7t5v0__endcap
XPHY_EDGE_ROW_6_Right_6 VPWR VGND gf180mcu_fd_sc_mcu7t5v0__endcap
X_645_ _645_/D _647_/CLK _645_/Q VPWR VPWR VGND VGND gf180mcu_fd_sc_mcu7t5v0__dffq_1
X_576_ _574_/Z _576_/A2 _636_/D VPWR VPWR VGND VGND gf180mcu_fd_sc_mcu7t5v0__nand2_1
XPHY_EDGE_ROW_33_Left_76 VPWR VGND gf180mcu_fd_sc_mcu7t5v0__endcap
XFILLER_22_146 VPWR VPWR VGND VGND gf180mcu_fd_sc_mcu7t5v0__fill_2
X_430_ _430_/A1 _430_/A2 _430_/A3 _513_/A2 VPWR VPWR VGND VGND gf180mcu_fd_sc_mcu7t5v0__nor3_4
X_361_ _391_/A1 _396_/A3 _391_/A3 _536_/A3 VPWR VPWR VGND VGND gf180mcu_fd_sc_mcu7t5v0__nor3_4
XFILLER_9_139 VPWR VPWR VGND VGND gf180mcu_fd_sc_mcu7t5v0__fill_1
X_628_ _639_/RN input1/Z _647_/D VPWR VPWR VGND VGND gf180mcu_fd_sc_mcu7t5v0__and2_1
X_559_ _630_/Q _617_/B _562_/A2 VPWR VPWR VGND VGND gf180mcu_fd_sc_mcu7t5v0__nand2_1
XFILLER_12_34 VPWR VPWR VGND VGND gf180mcu_fd_sc_mcu7t5v0__fill_1
X_344_ _345_/A1 _396_/A1 _344_/Z VPWR VPWR VGND VGND gf180mcu_fd_sc_mcu7t5v0__xor2_1
XFILLER_5_142 VPWR VPWR VGND VGND gf180mcu_fd_sc_mcu7t5v0__fillcap_32
X_413_ _643_/Q _413_/A2 _515_/A3 VPWR VPWR VGND VGND gf180mcu_fd_sc_mcu7t5v0__xnor2_1
XPHY_EDGE_ROW_20_Left_63 VPWR VGND gf180mcu_fd_sc_mcu7t5v0__endcap
XFILLER_2_101 VPWR VPWR VGND VGND gf180mcu_fd_sc_mcu7t5v0__fillcap_4
X_327_ _621_/A2 _532_/A1 _327_/B _435_/A2 VPWR VPWR VGND VGND gf180mcu_fd_sc_mcu7t5v0__oai21_1
Xload_slew43 _543_/A1 _551_/A1 VPWR VPWR VGND VGND gf180mcu_fd_sc_mcu7t5v0__buf_2
Xload_slew32 _401_/ZN _546_/B VPWR VPWR VGND VGND gf180mcu_fd_sc_mcu7t5v0__clkbuf_1
X_592_ _620_/A1 _590_/Z _608_/A1 VPWR VPWR VGND VGND gf180mcu_fd_sc_mcu7t5v0__nand2_1
XFILLER_6_69 VPWR VPWR VGND VGND gf180mcu_fd_sc_mcu7t5v0__fillcap_8
XFILLER_34_199 VPWR VPWR VGND VGND gf180mcu_fd_sc_mcu7t5v0__fill_1
XFILLER_34_133 VPWR VPWR VGND VGND gf180mcu_fd_sc_mcu7t5v0__fill_2
XFILLER_19_163 VPWR VPWR VGND VGND gf180mcu_fd_sc_mcu7t5v0__fill_1
X_575_ _636_/Q _575_/A2 _576_/A2 VPWR VPWR VGND VGND gf180mcu_fd_sc_mcu7t5v0__nand2_1
X_644_ _644_/D _644_/RN _646_/CLK _644_/Q VPWR VPWR VGND VGND gf180mcu_fd_sc_mcu7t5v0__dffrnq_2
XFILLER_15_78 VPWR VPWR VGND VGND gf180mcu_fd_sc_mcu7t5v0__fill_1
XFILLER_16_199 VPWR VPWR VGND VGND gf180mcu_fd_sc_mcu7t5v0__fill_1
XFILLER_16_177 VPWR VPWR VGND VGND gf180mcu_fd_sc_mcu7t5v0__fillcap_16
XFILLER_11_2 VPWR VPWR VGND VGND gf180mcu_fd_sc_mcu7t5v0__fillcap_4
X_360_ _391_/A1 _339_/Z _390_/A1 _430_/A2 _516_/A1 VPWR VPWR VGND VGND gf180mcu_fd_sc_mcu7t5v0__nand4_4
X_558_ _558_/A1 _558_/A2 _558_/A3 B[4] VPWR VPWR VGND VGND gf180mcu_fd_sc_mcu7t5v0__nand3_4
X_627_ _644_/RN _645_/Q _646_/D VPWR VPWR VGND VGND gf180mcu_fd_sc_mcu7t5v0__and2_1
X_489_ _500_/B _510_/B _489_/B _490_/A4 VPWR VPWR VGND VGND gf180mcu_fd_sc_mcu7t5v0__aoi21_1
X_343_ _582_/A1 _343_/A2 _644_/Q _345_/A1 VPWR VPWR VGND VGND gf180mcu_fd_sc_mcu7t5v0__oai21_2
XFILLER_5_198 VPWR VPWR VGND VGND gf180mcu_fd_sc_mcu7t5v0__fill_2
X_412_ _413_/A2 _643_/Q _412_/Z VPWR VPWR VGND VGND gf180mcu_fd_sc_mcu7t5v0__xor2_2
XFILLER_1_190 VPWR VPWR VGND VGND gf180mcu_fd_sc_mcu7t5v0__fillcap_8
X_326_ _330_/B _318_/Z _641_/Q _379_/C VPWR VPWR VGND VGND gf180mcu_fd_sc_mcu7t5v0__aoi21_2
XFILLER_18_67 VPWR VPWR VGND VGND gf180mcu_fd_sc_mcu7t5v0__fillcap_4
Xload_slew44 _406_/A2 _393_/A1 VPWR VPWR VGND VGND gf180mcu_fd_sc_mcu7t5v0__buf_2
Xload_slew11 _461_/A1 _462_/A1 VPWR VPWR VGND VGND gf180mcu_fd_sc_mcu7t5v0__buf_4
X_309_ _646_/Q _620_/A1 VPWR VPWR VGND VGND gf180mcu_fd_sc_mcu7t5v0__clkinv_1
X_591_ _620_/A1 _590_/Z _591_/Z VPWR VPWR VGND VGND gf180mcu_fd_sc_mcu7t5v0__and2_1
XFILLER_6_37 VPWR VPWR VGND VGND gf180mcu_fd_sc_mcu7t5v0__fillcap_32
XFILLER_25_134 VPWR VPWR VGND VGND gf180mcu_fd_sc_mcu7t5v0__fill_1
X_574_ _636_/Q _575_/A2 _574_/Z VPWR VPWR VGND VGND gf180mcu_fd_sc_mcu7t5v0__or2_1
X_643_ _643_/D _644_/RN _646_/CLK _643_/Q VPWR VPWR VGND VGND gf180mcu_fd_sc_mcu7t5v0__dffrnq_2
XFILLER_22_148 VPWR VPWR VGND VGND gf180mcu_fd_sc_mcu7t5v0__fill_1
X_557_ _557_/A1 _557_/A2 _558_/A3 VPWR VPWR VGND VGND gf180mcu_fd_sc_mcu7t5v0__nor2_1
X_626_ input2/Z _644_/RN _645_/D VPWR VPWR VGND VGND gf180mcu_fd_sc_mcu7t5v0__and2_1
X_488_ _466_/Z _499_/A2 _488_/A3 _488_/A4 _488_/Z VPWR VPWR VGND VGND gf180mcu_fd_sc_mcu7t5v0__and4_1
XFILLER_9_108 VPWR VPWR VGND VGND gf180mcu_fd_sc_mcu7t5v0__fill_1
XFILLER_13_148 VPWR VPWR VGND VGND gf180mcu_fd_sc_mcu7t5v0__fill_2
XFILLER_10_107 VPWR VPWR VGND VGND gf180mcu_fd_sc_mcu7t5v0__fillcap_8
X_411_ _544_/C _407_/Z _405_/Z _411_/A4 _411_/Z VPWR VPWR VGND VGND gf180mcu_fd_sc_mcu7t5v0__or4_4
X_342_ _640_/Q _342_/A2 _342_/Z VPWR VPWR VGND VGND gf180mcu_fd_sc_mcu7t5v0__xor2_1
X_609_ _617_/B _616_/A2 _609_/A3 _610_/B VPWR VPWR VGND VGND gf180mcu_fd_sc_mcu7t5v0__nand3_1
Xmax_cap9 _463_/A3 _461_/A3 VPWR VPWR VGND VGND gf180mcu_fd_sc_mcu7t5v0__buf_2
XFILLER_9_48 VPWR VPWR VGND VGND gf180mcu_fd_sc_mcu7t5v0__fill_2
X_325_ _641_/Q _330_/B _318_/Z _435_/A1 VPWR VPWR VGND VGND gf180mcu_fd_sc_mcu7t5v0__nand3_1
Xload_slew12 _461_/A1 _460_/A1 VPWR VPWR VGND VGND gf180mcu_fd_sc_mcu7t5v0__clkbuf_1
Xclkload0 _646_/CLK clkload0/Z VPWR VPWR VGND VGND gf180mcu_fd_sc_mcu7t5v0__clkbuf_2
XFILLER_1_2 VPWR VPWR VGND VGND gf180mcu_fd_sc_mcu7t5v0__fillcap_64
Xload_slew34 _380_/Z _543_/A2 VPWR VPWR VGND VGND gf180mcu_fd_sc_mcu7t5v0__buf_1
XFILLER_28_198 VPWR VPWR VGND VGND gf180mcu_fd_sc_mcu7t5v0__fill_2
X_590_ _641_/Q _593_/A3 _590_/Z VPWR VPWR VGND VGND gf180mcu_fd_sc_mcu7t5v0__xor2_1
X_573_ _579_/A1 _579_/A2 _617_/B _575_/A2 VPWR VPWR VGND VGND gf180mcu_fd_sc_mcu7t5v0__oai21_1
XPHY_EDGE_ROW_28_Right_28 VPWR VGND gf180mcu_fd_sc_mcu7t5v0__endcap
X_642_ _642_/D _644_/RN _642_/CLK _642_/Q VPWR VPWR VGND VGND gf180mcu_fd_sc_mcu7t5v0__dffrnq_1
XPHY_EDGE_ROW_19_Right_19 VPWR VGND gf180mcu_fd_sc_mcu7t5v0__endcap
XPHY_EDGE_ROW_37_Right_37 VPWR VGND gf180mcu_fd_sc_mcu7t5v0__endcap
XFILLER_7_81 VPWR VPWR VGND VGND gf180mcu_fd_sc_mcu7t5v0__fillcap_4
XFILLER_26_46 VPWR VPWR VGND VGND gf180mcu_fd_sc_mcu7t5v0__fill_1
X_625_ _625_/A1 _625_/A2 _623_/Z _625_/B _644_/D VPWR VPWR VGND VGND gf180mcu_fd_sc_mcu7t5v0__oai31_1
X_556_ _556_/A1 _556_/A2 _556_/A3 _557_/A2 VPWR VPWR VGND VGND gf180mcu_fd_sc_mcu7t5v0__nand3_1
X_487_ _487_/A1 _487_/A2 _502_/B _543_/B2 _532_/B _488_/A4 VPWR VPWR VGND VGND gf180mcu_fd_sc_mcu7t5v0__aoi221_1
XFILLER_8_131 VPWR VPWR VGND VGND gf180mcu_fd_sc_mcu7t5v0__fill_1
XFILLER_8_197 VPWR VPWR VGND VGND gf180mcu_fd_sc_mcu7t5v0__fill_2
XFILLER_12_193 VPWR VPWR VGND VGND gf180mcu_fd_sc_mcu7t5v0__fillcap_4
XFILLER_37_67 VPWR VPWR VGND VGND gf180mcu_fd_sc_mcu7t5v0__fill_2
X_341_ _342_/A2 _640_/Q _341_/ZN VPWR VPWR VGND VGND gf180mcu_fd_sc_mcu7t5v0__xnor2_2
X_410_ _415_/A1 _410_/A2 _410_/B _411_/A4 VPWR VPWR VGND VGND gf180mcu_fd_sc_mcu7t5v0__aoi21_1
XTAP_TAPCELL_ROW_5_101 VPWR VGND gf180mcu_fd_sc_mcu7t5v0__filltie
XFILLER_10_119 VPWR VPWR VGND VGND gf180mcu_fd_sc_mcu7t5v0__fill_2
XFILLER_12_37 VPWR VPWR VGND VGND gf180mcu_fd_sc_mcu7t5v0__fill_2
X_608_ _608_/A1 _595_/Z _606_/B _609_/A3 VPWR VPWR VGND VGND gf180mcu_fd_sc_mcu7t5v0__nand3_1
X_539_ _466_/Z _529_/Z _539_/A3 _539_/A4 B[2] VPWR VPWR VGND VGND gf180mcu_fd_sc_mcu7t5v0__nand4_4
XFILLER_23_69 VPWR VPWR VGND VGND gf180mcu_fd_sc_mcu7t5v0__fill_1
XPHY_EDGE_ROW_24_Left_67 VPWR VGND gf180mcu_fd_sc_mcu7t5v0__endcap
X_324_ _331_/A2 _621_/A2 _327_/B _379_/B VPWR VPWR VGND VGND gf180mcu_fd_sc_mcu7t5v0__nor3_4
Xclkload1 _647_/CLK clkload1/Z VPWR VPWR VGND VGND gf180mcu_fd_sc_mcu7t5v0__clkbuf_2
Xload_slew35 _495_/A1 _500_/B VPWR VPWR VGND VGND gf180mcu_fd_sc_mcu7t5v0__clkbuf_2
XFILLER_1_72 VPWR VPWR VGND VGND gf180mcu_fd_sc_mcu7t5v0__fillcap_64
XTAP_TAPCELL_ROW_38_183 VPWR VGND gf180mcu_fd_sc_mcu7t5v0__filltie
XFILLER_20_37 VPWR VPWR VGND VGND gf180mcu_fd_sc_mcu7t5v0__fill_2
XTAP_TAPCELL_ROW_29_161 VPWR VGND gf180mcu_fd_sc_mcu7t5v0__filltie
XPHY_EDGE_ROW_27_Left_70 VPWR VGND gf180mcu_fd_sc_mcu7t5v0__endcap
XPHY_EDGE_ROW_11_Left_54 VPWR VGND gf180mcu_fd_sc_mcu7t5v0__endcap
X_572_ _635_/Q _634_/Q _579_/A2 VPWR VPWR VGND VGND gf180mcu_fd_sc_mcu7t5v0__nand2_1
XTAP_TAPCELL_ROW_26_153 VPWR VGND gf180mcu_fd_sc_mcu7t5v0__filltie
X_641_ _641_/D _644_/RN _646_/CLK _641_/Q VPWR VPWR VGND VGND gf180mcu_fd_sc_mcu7t5v0__dffrnq_2
XFILLER_16_103 VPWR VPWR VGND VGND gf180mcu_fd_sc_mcu7t5v0__fill_2
XTAP_TAPCELL_ROW_17_131 VPWR VGND gf180mcu_fd_sc_mcu7t5v0__filltie
XFILLER_7_93 VPWR VPWR VGND VGND gf180mcu_fd_sc_mcu7t5v0__fillcap_16
XFILLER_21_194 VPWR VPWR VGND VGND gf180mcu_fd_sc_mcu7t5v0__fillcap_4
XTAP_TAPCELL_ROW_8_110 VPWR VGND gf180mcu_fd_sc_mcu7t5v0__filltie
X_486_ _501_/A4 _491_/A2 _505_/B _535_/B _488_/A3 VPWR VPWR VGND VGND gf180mcu_fd_sc_mcu7t5v0__aoi22_1
XFILLER_12_172 VPWR VPWR VGND VGND gf180mcu_fd_sc_mcu7t5v0__fill_2
X_555_ _555_/A1 _555_/A2 _557_/A1 VPWR VPWR VGND VGND gf180mcu_fd_sc_mcu7t5v0__nand2_1
XTAP_TAPCELL_ROW_14_123 VPWR VGND gf180mcu_fd_sc_mcu7t5v0__filltie
X_624_ _330_/B _625_/A1 _625_/B VPWR VPWR VGND VGND gf180mcu_fd_sc_mcu7t5v0__nand2_1
XTAP_TAPCELL_ROW_5_102 VPWR VGND gf180mcu_fd_sc_mcu7t5v0__filltie
X_340_ _584_/A1 _584_/A2 _477_/A1 _644_/Q _342_/A2 VPWR VPWR VGND VGND gf180mcu_fd_sc_mcu7t5v0__oai31_4
X_538_ _538_/A1 _506_/Z _538_/B1 _512_/B _538_/C _539_/A4 VPWR VPWR VGND VGND gf180mcu_fd_sc_mcu7t5v0__aoi221_4
X_607_ _591_/Z _619_/A2 _619_/B _616_/A2 VPWR VPWR VGND VGND gf180mcu_fd_sc_mcu7t5v0__oai21_1
X_469_ _507_/A1 _491_/A2 _470_/A2 VPWR VPWR VGND VGND gf180mcu_fd_sc_mcu7t5v0__nand2_1
Xfanout60 _637_/Q _477_/A1 VPWR VPWR VGND VGND gf180mcu_fd_sc_mcu7t5v0__buf_4
X_323_ _330_/B _413_/A2 _643_/Q _478_/C VPWR VPWR VGND VGND gf180mcu_fd_sc_mcu7t5v0__mux2_2
XPHY_EDGE_ROW_41_Left_84 VPWR VGND gf180mcu_fd_sc_mcu7t5v0__endcap
Xclkload2 _648_/CLK clkload2/Z VPWR VPWR VGND VGND gf180mcu_fd_sc_mcu7t5v0__clkbuf_2
XFILLER_18_37 VPWR VPWR VGND VGND gf180mcu_fd_sc_mcu7t5v0__fill_2
Xload_slew36 _487_/A1 _482_/B VPWR VPWR VGND VGND gf180mcu_fd_sc_mcu7t5v0__buf_2
Xload_slew14 _495_/B _505_/B VPWR VPWR VGND VGND gf180mcu_fd_sc_mcu7t5v0__clkbuf_2
XTAP_TAPCELL_ROW_38_184 VPWR VGND gf180mcu_fd_sc_mcu7t5v0__filltie
XTAP_TAPCELL_ROW_29_162 VPWR VGND gf180mcu_fd_sc_mcu7t5v0__filltie
XFILLER_40_107 VPWR VPWR VGND VGND gf180mcu_fd_sc_mcu7t5v0__fill_1
XTAP_TAPCELL_ROW_35_176 VPWR VGND gf180mcu_fd_sc_mcu7t5v0__filltie
X_571_ _635_/Q _571_/A2 _635_/D VPWR VPWR VGND VGND gf180mcu_fd_sc_mcu7t5v0__xnor2_1
X_640_ _640_/D _644_/RN _642_/CLK _640_/Q VPWR VPWR VGND VGND gf180mcu_fd_sc_mcu7t5v0__dffrnq_2
XTAP_TAPCELL_ROW_26_154 VPWR VGND gf180mcu_fd_sc_mcu7t5v0__filltie
XPHY_EDGE_ROW_1_Right_1 VPWR VGND gf180mcu_fd_sc_mcu7t5v0__endcap
XTAP_TAPCELL_ROW_40_190 VPWR VGND gf180mcu_fd_sc_mcu7t5v0__filltie
XTAP_TAPCELL_ROW_32_168 VPWR VGND gf180mcu_fd_sc_mcu7t5v0__filltie
XFILLER_22_107 VPWR VPWR VGND VGND gf180mcu_fd_sc_mcu7t5v0__fill_1
XTAP_TAPCELL_ROW_17_132 VPWR VGND gf180mcu_fd_sc_mcu7t5v0__filltie
XFILLER_7_72 VPWR VPWR VGND VGND gf180mcu_fd_sc_mcu7t5v0__fill_2
XFILLER_11_6 VPWR VPWR VGND VGND gf180mcu_fd_sc_mcu7t5v0__fill_2
XTAP_TAPCELL_ROW_23_146 VPWR VGND gf180mcu_fd_sc_mcu7t5v0__filltie
X_485_ _536_/A4 _448_/B _513_/A2 _502_/B _493_/A3 VPWR VPWR VGND VGND gf180mcu_fd_sc_mcu7t5v0__aoi22_1
X_554_ _541_/B _416_/Z _432_/B _554_/B2 _555_/A2 VPWR VPWR VGND VGND gf180mcu_fd_sc_mcu7t5v0__aoi22_1
XFILLER_8_155 VPWR VPWR VGND VGND gf180mcu_fd_sc_mcu7t5v0__fillcap_16
XFILLER_8_177 VPWR VPWR VGND VGND gf180mcu_fd_sc_mcu7t5v0__fillcap_16
XFILLER_8_199 VPWR VPWR VGND VGND gf180mcu_fd_sc_mcu7t5v0__fill_1
X_623_ _623_/A1 _623_/A2 _622_/B _623_/Z VPWR VPWR VGND VGND gf180mcu_fd_sc_mcu7t5v0__and3_1
XTAP_TAPCELL_ROW_14_124 VPWR VGND gf180mcu_fd_sc_mcu7t5v0__filltie
XTAP_TAPCELL_ROW_20_138 VPWR VGND gf180mcu_fd_sc_mcu7t5v0__filltie
XFILLER_12_39 VPWR VPWR VGND VGND gf180mcu_fd_sc_mcu7t5v0__fill_1
XFILLER_37_69 VPWR VPWR VGND VGND gf180mcu_fd_sc_mcu7t5v0__fill_1
XFILLER_5_136 VPWR VPWR VGND VGND gf180mcu_fd_sc_mcu7t5v0__fillcap_4
XTAP_TAPCELL_ROW_11_116 VPWR VGND gf180mcu_fd_sc_mcu7t5v0__filltie
X_606_ _608_/A1 _595_/Z _606_/B _617_/A2 VPWR VPWR VGND VGND gf180mcu_fd_sc_mcu7t5v0__aoi21_1
X_468_ _382_/Z _397_/Z _468_/B _542_/A1 VPWR VPWR VGND VGND gf180mcu_fd_sc_mcu7t5v0__oai21_1
X_537_ _410_/B _537_/A2 _537_/B _538_/C VPWR VPWR VGND VGND gf180mcu_fd_sc_mcu7t5v0__oai21_1
X_399_ _535_/A1 _398_/Z _552_/A2 VPWR VPWR VGND VGND gf180mcu_fd_sc_mcu7t5v0__nand2_1
XFILLER_9_18 VPWR VPWR VGND VGND gf180mcu_fd_sc_mcu7t5v0__fillcap_4
X_322_ _643_/Q _413_/A2 _322_/B _453_/A1 VPWR VPWR VGND VGND gf180mcu_fd_sc_mcu7t5v0__aoi21_1
Xfanout61 _637_/Q _343_/A2 VPWR VPWR VGND VGND gf180mcu_fd_sc_mcu7t5v0__buf_4
Xfanout50 _450_/B2 _532_/A1 VPWR VPWR VGND VGND gf180mcu_fd_sc_mcu7t5v0__buf_2
XFILLER_20_39 VPWR VPWR VGND VGND gf180mcu_fd_sc_mcu7t5v0__fill_1
XTAP_TAPCELL_ROW_38_185 VPWR VGND gf180mcu_fd_sc_mcu7t5v0__filltie
XFILLER_28_102 VPWR VPWR VGND VGND gf180mcu_fd_sc_mcu7t5v0__fill_2
XFILLER_10_61 VPWR VPWR VGND VGND gf180mcu_fd_sc_mcu7t5v0__fillcap_4
XFILLER_32_2 VPWR VPWR VGND VGND gf180mcu_fd_sc_mcu7t5v0__fill_2
XTAP_TAPCELL_ROW_35_177 VPWR VGND gf180mcu_fd_sc_mcu7t5v0__filltie
X_570_ _634_/Q _570_/A2 _634_/D VPWR VPWR VGND VGND gf180mcu_fd_sc_mcu7t5v0__xor2_1
Xclkbuf_0_clk clk clkbuf_0_clk/Z VPWR VPWR VGND VGND gf180mcu_fd_sc_mcu7t5v0__clkbuf_16
XTAP_TAPCELL_ROW_26_155 VPWR VGND gf180mcu_fd_sc_mcu7t5v0__filltie
XTAP_TAPCELL_ROW_32_169 VPWR VGND gf180mcu_fd_sc_mcu7t5v0__filltie
XFILLER_26_16 VPWR VPWR VGND VGND gf180mcu_fd_sc_mcu7t5v0__fill_2
XPHY_EDGE_ROW_24_Right_24 VPWR VGND gf180mcu_fd_sc_mcu7t5v0__endcap
XTAP_TAPCELL_ROW_23_147 VPWR VGND gf180mcu_fd_sc_mcu7t5v0__filltie
XFILLER_7_51 VPWR VPWR VGND VGND gf180mcu_fd_sc_mcu7t5v0__fill_2
XPHY_EDGE_ROW_15_Right_15 VPWR VGND gf180mcu_fd_sc_mcu7t5v0__endcap
XPHY_EDGE_ROW_42_Right_42 VPWR VGND gf180mcu_fd_sc_mcu7t5v0__endcap
XPHY_EDGE_ROW_33_Right_33 VPWR VGND gf180mcu_fd_sc_mcu7t5v0__endcap
X_553_ _544_/C _405_/Z _553_/A3 _558_/A2 VPWR VPWR VGND VGND gf180mcu_fd_sc_mcu7t5v0__nor3_2
X_484_ _484_/A1 _412_/Z _478_/B _531_/C VPWR VPWR VGND VGND gf180mcu_fd_sc_mcu7t5v0__nor3_1
X_622_ _623_/A1 _623_/A2 _622_/B _625_/A2 VPWR VPWR VGND VGND gf180mcu_fd_sc_mcu7t5v0__aoi21_1
XFILLER_12_174 VPWR VPWR VGND VGND gf180mcu_fd_sc_mcu7t5v0__fill_1
XTAP_TAPCELL_ROW_14_125 VPWR VGND gf180mcu_fd_sc_mcu7t5v0__filltie
XTAP_TAPCELL_ROW_20_139 VPWR VGND gf180mcu_fd_sc_mcu7t5v0__filltie
XTAP_TAPCELL_ROW_3_96 VPWR VGND gf180mcu_fd_sc_mcu7t5v0__filltie
XTAP_TAPCELL_ROW_11_117 VPWR VGND gf180mcu_fd_sc_mcu7t5v0__filltie
X_398_ _540_/B _527_/A2 _395_/Z _398_/Z VPWR VPWR VGND VGND gf180mcu_fd_sc_mcu7t5v0__or3_4
X_605_ _620_/A1 _601_/Z _606_/B VPWR VPWR VGND VGND gf180mcu_fd_sc_mcu7t5v0__xor2_1
X_536_ _536_/A1 _352_/Z _536_/A3 _536_/A4 _537_/A2 VPWR VPWR VGND VGND gf180mcu_fd_sc_mcu7t5v0__nor4_1
X_467_ _525_/B2 _527_/A2 _467_/Z VPWR VPWR VGND VGND gf180mcu_fd_sc_mcu7t5v0__or2_1
XFILLER_2_107 VPWR VPWR VGND VGND gf180mcu_fd_sc_mcu7t5v0__fillcap_64
Xfanout62 input3/Z _644_/RN VPWR VPWR VGND VGND gf180mcu_fd_sc_mcu7t5v0__dlyb_1
XTAP_TAPCELL_ROW_0_86 VPWR VGND gf180mcu_fd_sc_mcu7t5v0__filltie
X_321_ _643_/Q _621_/A2 _322_/B VPWR VPWR VGND VGND gf180mcu_fd_sc_mcu7t5v0__nor2_1
XFILLER_13_72 VPWR VPWR VGND VGND gf180mcu_fd_sc_mcu7t5v0__fill_2
XFILLER_18_39 VPWR VPWR VGND VGND gf180mcu_fd_sc_mcu7t5v0__fill_1
X_519_ _520_/A1 _519_/A2 _519_/B _521_/A3 VPWR VPWR VGND VGND gf180mcu_fd_sc_mcu7t5v0__aoi21_1
XFILLER_24_60 VPWR VPWR VGND VGND gf180mcu_fd_sc_mcu7t5v0__fill_1
Xload_slew27 _464_/B _465_/A2 VPWR VPWR VGND VGND gf180mcu_fd_sc_mcu7t5v0__buf_2
Xload_slew38 _492_/A1 _527_/A2 VPWR VPWR VGND VGND gf180mcu_fd_sc_mcu7t5v0__buf_2
Xload_slew16 _538_/A1 _491_/A2 VPWR VPWR VGND VGND gf180mcu_fd_sc_mcu7t5v0__buf_1
XFILLER_25_2 VPWR VPWR VGND VGND gf180mcu_fd_sc_mcu7t5v0__fill_2
XFILLER_21_72 VPWR VPWR VGND VGND gf180mcu_fd_sc_mcu7t5v0__fill_1
XFILLER_21_50 VPWR VPWR VGND VGND gf180mcu_fd_sc_mcu7t5v0__fill_1
XFILLER_11_8 VPWR VPWR VGND VGND gf180mcu_fd_sc_mcu7t5v0__fill_1
XFILLER_7_74 VPWR VPWR VGND VGND gf180mcu_fd_sc_mcu7t5v0__fill_1
XPHY_EDGE_ROW_15_Left_58 VPWR VGND gf180mcu_fd_sc_mcu7t5v0__endcap
X_483_ _483_/A1 _483_/A2 _543_/A2 _496_/A2 VPWR VPWR VGND VGND gf180mcu_fd_sc_mcu7t5v0__nand3_1
X_552_ _552_/A1 _552_/A2 _552_/A3 _552_/A4 _553_/A3 VPWR VPWR VGND VGND gf180mcu_fd_sc_mcu7t5v0__nand4_1
XFILLER_8_102 VPWR VPWR VGND VGND gf180mcu_fd_sc_mcu7t5v0__fill_2
X_621_ _646_/Q _621_/A2 _621_/A3 _622_/B VPWR VPWR VGND VGND gf180mcu_fd_sc_mcu7t5v0__xor3_1
XFILLER_12_120 VPWR VPWR VGND VGND gf180mcu_fd_sc_mcu7t5v0__fill_2
XTAP_TAPCELL_ROW_3_97 VPWR VGND gf180mcu_fd_sc_mcu7t5v0__filltie
XFILLER_12_197 VPWR VPWR VGND VGND gf180mcu_fd_sc_mcu7t5v0__fill_2
XFILLER_7_190 VPWR VPWR VGND VGND gf180mcu_fd_sc_mcu7t5v0__fillcap_8
Xclkbuf_2_0__f_clk clkbuf_0_clk/Z _642_/CLK VPWR VPWR VGND VGND gf180mcu_fd_sc_mcu7t5v0__clkbuf_16
X_466_ _466_/A1 _545_/A2 _466_/Z VPWR VPWR VGND VGND gf180mcu_fd_sc_mcu7t5v0__and2_1
X_604_ _646_/Q _601_/Z _619_/B VPWR VPWR VGND VGND gf180mcu_fd_sc_mcu7t5v0__xor2_1
X_535_ _535_/A1 _464_/B _535_/B _537_/B VPWR VPWR VGND VGND gf180mcu_fd_sc_mcu7t5v0__oai21_1
XFILLER_4_193 VPWR VPWR VGND VGND gf180mcu_fd_sc_mcu7t5v0__fillcap_4
XFILLER_4_171 VPWR VPWR VGND VGND gf180mcu_fd_sc_mcu7t5v0__fillcap_4
X_397_ _527_/A2 _395_/Z _397_/Z VPWR VPWR VGND VGND gf180mcu_fd_sc_mcu7t5v0__or2_1
XPHY_EDGE_ROW_18_Left_61 VPWR VGND gf180mcu_fd_sc_mcu7t5v0__endcap
Xfanout63 input3/Z _639_/RN VPWR VPWR VGND VGND gf180mcu_fd_sc_mcu7t5v0__dlyb_1
X_320_ _318_/Z _642_/Q _641_/Q _330_/B _413_/A2 VPWR VPWR VGND VGND gf180mcu_fd_sc_mcu7t5v0__oai31_4
XFILLER_1_174 VPWR VPWR VGND VGND gf180mcu_fd_sc_mcu7t5v0__fillcap_16
XTAP_TAPCELL_ROW_0_87 VPWR VGND gf180mcu_fd_sc_mcu7t5v0__filltie
X_518_ _468_/B _538_/B1 _517_/Z _535_/A1 _521_/A2 VPWR VPWR VGND VGND gf180mcu_fd_sc_mcu7t5v0__aoi22_1
X_449_ _449_/A1 _515_/A1 _412_/Z _543_/C1 VPWR VPWR VGND VGND gf180mcu_fd_sc_mcu7t5v0__nor3_2
XFILLER_34_28 VPWR VPWR VGND VGND gf180mcu_fd_sc_mcu7t5v0__fill_1
XPHY_EDGE_ROW_3_Left_46 VPWR VGND gf180mcu_fd_sc_mcu7t5v0__endcap
Xload_slew17 _468_/B _538_/A1 VPWR VPWR VGND VGND gf180mcu_fd_sc_mcu7t5v0__buf_2
Xload_slew28 _507_/B _464_/B VPWR VPWR VGND VGND gf180mcu_fd_sc_mcu7t5v0__buf_2
XFILLER_37_137 VPWR VPWR VGND VGND gf180mcu_fd_sc_mcu7t5v0__fill_2
XFILLER_28_104 VPWR VPWR VGND VGND gf180mcu_fd_sc_mcu7t5v0__fill_1
XFILLER_10_41 VPWR VPWR VGND VGND gf180mcu_fd_sc_mcu7t5v0__fill_2
XFILLER_32_4 VPWR VPWR VGND VGND gf180mcu_fd_sc_mcu7t5v0__fill_1
XFILLER_18_2 VPWR VPWR VGND VGND gf180mcu_fd_sc_mcu7t5v0__fill_2
XFILLER_7_53 VPWR VPWR VGND VGND gf180mcu_fd_sc_mcu7t5v0__fill_1
XFILLER_21_198 VPWR VPWR VGND VGND gf180mcu_fd_sc_mcu7t5v0__fill_2
XFILLER_21_154 VPWR VPWR VGND VGND gf180mcu_fd_sc_mcu7t5v0__fillcap_4
X_551_ _551_/A1 _551_/A2 _491_/B _551_/B1 _512_/B _558_/A1 VPWR VPWR VGND VGND gf180mcu_fd_sc_mcu7t5v0__oai32_4
XPHY_EDGE_ROW_5_Right_5 VPWR VGND gf180mcu_fd_sc_mcu7t5v0__endcap
X_620_ _620_/A1 _613_/Z _620_/B _623_/A2 VPWR VPWR VGND VGND gf180mcu_fd_sc_mcu7t5v0__aoi21_1
XPHY_EDGE_ROW_32_Left_75 VPWR VGND gf180mcu_fd_sc_mcu7t5v0__endcap
X_482_ _482_/A1 _543_/B2 _513_/A2 _482_/B _493_/A2 VPWR VPWR VGND VGND gf180mcu_fd_sc_mcu7t5v0__oai31_1
XFILLER_8_125 VPWR VPWR VGND VGND gf180mcu_fd_sc_mcu7t5v0__fillcap_4
X_396_ _396_/A1 _396_/A2 _396_/A3 _478_/A2 VPWR VPWR VGND VGND gf180mcu_fd_sc_mcu7t5v0__nand3_1
XFILLER_27_50 VPWR VPWR VGND VGND gf180mcu_fd_sc_mcu7t5v0__fill_2
X_465_ _525_/B2 _465_/A2 _512_/B _465_/B2 _545_/A2 VPWR VPWR VGND VGND gf180mcu_fd_sc_mcu7t5v0__aoi22_1
X_603_ _620_/B _616_/A1 VPWR VPWR VGND VGND gf180mcu_fd_sc_mcu7t5v0__clkinv_1
X_534_ _534_/A1 _534_/A2 _539_/A3 VPWR VPWR VGND VGND gf180mcu_fd_sc_mcu7t5v0__nor2_1
XFILLER_1_142 VPWR VPWR VGND VGND gf180mcu_fd_sc_mcu7t5v0__fillcap_32
Xfanout31 _401_/ZN _502_/B VPWR VPWR VGND VGND gf180mcu_fd_sc_mcu7t5v0__buf_2
XFILLER_13_74 VPWR VPWR VGND VGND gf180mcu_fd_sc_mcu7t5v0__fill_1
X_448_ _550_/B _432_/B _448_/B _452_/A4 VPWR VPWR VGND VGND gf180mcu_fd_sc_mcu7t5v0__oai21_1
XTAP_TAPCELL_ROW_0_88 VPWR VGND gf180mcu_fd_sc_mcu7t5v0__filltie
X_517_ _536_/A3 _517_/A2 _517_/Z VPWR VPWR VGND VGND gf180mcu_fd_sc_mcu7t5v0__or2_1
X_379_ _435_/A3 _435_/A4 _379_/B _379_/C _420_/A1 VPWR VPWR VGND VGND gf180mcu_fd_sc_mcu7t5v0__aoi211_2
XFILLER_1_66 VPWR VPWR VGND VGND gf180mcu_fd_sc_mcu7t5v0__fillcap_4
XFILLER_42_196 VPWR VPWR VGND VGND gf180mcu_fd_sc_mcu7t5v0__fillcap_4
XFILLER_25_4 VPWR VPWR VGND VGND gf180mcu_fd_sc_mcu7t5v0__fill_1
XFILLER_7_43 VPWR VPWR VGND VGND gf180mcu_fd_sc_mcu7t5v0__fillcap_8
XFILLER_32_51 VPWR VPWR VGND VGND gf180mcu_fd_sc_mcu7t5v0__fill_2
X_550_ _448_/B _554_/B2 _550_/B _556_/A3 VPWR VPWR VGND VGND gf180mcu_fd_sc_mcu7t5v0__oai21_1
XPHY_EDGE_ROW_20_Right_20 VPWR VGND gf180mcu_fd_sc_mcu7t5v0__endcap
X_481_ _369_/Z _491_/A2 _505_/B _517_/A2 _499_/A2 VPWR VPWR VGND VGND gf180mcu_fd_sc_mcu7t5v0__aoi22_1
XFILLER_8_104 VPWR VPWR VGND VGND gf180mcu_fd_sc_mcu7t5v0__fill_1
XFILLER_12_122 VPWR VPWR VGND VGND gf180mcu_fd_sc_mcu7t5v0__fill_1
XFILLER_12_177 VPWR VPWR VGND VGND gf180mcu_fd_sc_mcu7t5v0__fillcap_16
XFILLER_12_199 VPWR VPWR VGND VGND gf180mcu_fd_sc_mcu7t5v0__fill_1
XPHY_EDGE_ROW_11_Right_11 VPWR VGND gf180mcu_fd_sc_mcu7t5v0__endcap
X_464_ _352_/Z _504_/A2 _464_/B _466_/A1 VPWR VPWR VGND VGND gf180mcu_fd_sc_mcu7t5v0__oai21_1
X_533_ _533_/A1 _404_/B _533_/A3 _533_/A4 _534_/A2 VPWR VPWR VGND VGND gf180mcu_fd_sc_mcu7t5v0__nand4_1
X_602_ _646_/Q _601_/Z _620_/B VPWR VPWR VGND VGND gf180mcu_fd_sc_mcu7t5v0__nor2_1
X_395_ _396_/A1 _396_/A2 _395_/A3 _395_/Z VPWR VPWR VGND VGND gf180mcu_fd_sc_mcu7t5v0__and3_1
X_516_ _516_/A1 _516_/A2 _538_/B1 VPWR VPWR VGND VGND gf180mcu_fd_sc_mcu7t5v0__nand2_1
XFILLER_1_198 VPWR VPWR VGND VGND gf180mcu_fd_sc_mcu7t5v0__fill_2
XTAP_TAPCELL_ROW_0_89 VPWR VGND gf180mcu_fd_sc_mcu7t5v0__filltie
XFILLER_8_2 VPWR VPWR VGND VGND gf180mcu_fd_sc_mcu7t5v0__fillcap_32
X_447_ _550_/B _448_/B _547_/A2 VPWR VPWR VGND VGND gf180mcu_fd_sc_mcu7t5v0__nand2_1
X_378_ _487_/A1 _385_/A2 _552_/A1 VPWR VPWR VGND VGND gf180mcu_fd_sc_mcu7t5v0__nand2_1
Xload_slew19 _543_/C1 _508_/A2 VPWR VPWR VGND VGND gf180mcu_fd_sc_mcu7t5v0__clkbuf_2
XFILLER_37_139 VPWR VPWR VGND VGND gf180mcu_fd_sc_mcu7t5v0__fill_1
XFILLER_19_85 VPWR VPWR VGND VGND gf180mcu_fd_sc_mcu7t5v0__fillcap_4
XFILLER_10_87 VPWR VPWR VGND VGND gf180mcu_fd_sc_mcu7t5v0__fill_2
XFILLER_18_4 VPWR VPWR VGND VGND gf180mcu_fd_sc_mcu7t5v0__fill_1
XFILLER_32_74 VPWR VPWR VGND VGND gf180mcu_fd_sc_mcu7t5v0__fill_1
X_480_ _520_/A2 _527_/A2 _502_/B _511_/A2 VPWR VPWR VGND VGND gf180mcu_fd_sc_mcu7t5v0__oai21_1
XFILLER_27_52 VPWR VPWR VGND VGND gf180mcu_fd_sc_mcu7t5v0__fill_1
X_601_ _642_/Q _601_/A2 _601_/Z VPWR VPWR VGND VGND gf180mcu_fd_sc_mcu7t5v0__xor2_1
X_463_ _463_/A1 _463_/A2 _463_/A3 wire4/I VPWR VPWR VGND VGND gf180mcu_fd_sc_mcu7t5v0__nor3_4
X_394_ _425_/A3 _424_/A2 _350_/Z _492_/A1 VPWR VPWR VGND VGND gf180mcu_fd_sc_mcu7t5v0__nor3_4
X_532_ _532_/A1 _538_/A1 _532_/B _533_/A4 VPWR VPWR VGND VGND gf180mcu_fd_sc_mcu7t5v0__aoi21_1
XFILLER_4_34 VPWR VPWR VGND VGND gf180mcu_fd_sc_mcu7t5v0__fill_1
Xfanout55 _648_/Q _617_/B VPWR VPWR VGND VGND gf180mcu_fd_sc_mcu7t5v0__dlyb_1
Xfanout33 _380_/Z _535_/A1 VPWR VPWR VGND VGND gf180mcu_fd_sc_mcu7t5v0__buf_4
Xfanout22 _436_/ZN _510_/B VPWR VPWR VGND VGND gf180mcu_fd_sc_mcu7t5v0__buf_2
X_446_ _512_/B _432_/B _530_/A3 VPWR VPWR VGND VGND gf180mcu_fd_sc_mcu7t5v0__nand2_1
X_377_ _391_/A1 _415_/A1 _484_/A1 _377_/B2 _377_/C _385_/A2 VPWR VPWR VGND VGND gf180mcu_fd_sc_mcu7t5v0__oai221_4
X_515_ _515_/A1 _369_/Z _515_/A3 _521_/A1 VPWR VPWR VGND VGND gf180mcu_fd_sc_mcu7t5v0__nand3_1
X_429_ _541_/B _454_/A2 _552_/A4 VPWR VPWR VGND VGND gf180mcu_fd_sc_mcu7t5v0__nand2_1
Xinput1 enable input1/Z VPWR VPWR VGND VGND gf180mcu_fd_sc_mcu7t5v0__dlyb_1
XFILLER_35_30 VPWR VPWR VGND VGND gf180mcu_fd_sc_mcu7t5v0__fill_1
XFILLER_18_184 VPWR VPWR VGND VGND gf180mcu_fd_sc_mcu7t5v0__fillcap_16
XFILLER_24_198 VPWR VPWR VGND VGND gf180mcu_fd_sc_mcu7t5v0__fill_2
XFILLER_15_198 VPWR VPWR VGND VGND gf180mcu_fd_sc_mcu7t5v0__fill_2
XFILLER_7_34 VPWR VPWR VGND VGND gf180mcu_fd_sc_mcu7t5v0__fillcap_4
XFILLER_32_31 VPWR VPWR VGND VGND gf180mcu_fd_sc_mcu7t5v0__fillcap_4
XFILLER_16_21 VPWR VPWR VGND VGND gf180mcu_fd_sc_mcu7t5v0__fill_1
XPHY_EDGE_ROW_9_Right_9 VPWR VGND gf180mcu_fd_sc_mcu7t5v0__endcap
XPHY_EDGE_ROW_36_Left_79 VPWR VGND gf180mcu_fd_sc_mcu7t5v0__endcap
X_462_ _462_/A1 _463_/A2 _457_/Z wire5/I VPWR VPWR VGND VGND gf180mcu_fd_sc_mcu7t5v0__nor3_4
X_393_ _393_/A1 _430_/A3 _393_/B _393_/C _491_/A1 VPWR VPWR VGND VGND gf180mcu_fd_sc_mcu7t5v0__aoi211_4
X_531_ _551_/A2 _535_/A1 _467_/Z _495_/B _531_/C _533_/A3 VPWR VPWR VGND VGND gf180mcu_fd_sc_mcu7t5v0__aoi221_1
XFILLER_4_197 VPWR VPWR VGND VGND gf180mcu_fd_sc_mcu7t5v0__fill_2
X_600_ _331_/C _601_/A2 _614_/A3 VPWR VPWR VGND VGND gf180mcu_fd_sc_mcu7t5v0__nor2_1
Xfanout45 _345_/ZN _393_/B VPWR VPWR VGND VGND gf180mcu_fd_sc_mcu7t5v0__buf_8
Xfanout23 _436_/ZN _554_/B2 VPWR VPWR VGND VGND gf180mcu_fd_sc_mcu7t5v0__buf_1
Xfanout56 _644_/Q _330_/B VPWR VPWR VGND VGND gf180mcu_fd_sc_mcu7t5v0__buf_4
X_514_ _514_/A1 _514_/A2 _522_/A3 VPWR VPWR VGND VGND gf180mcu_fd_sc_mcu7t5v0__nand2_1
X_445_ _582_/A1 _347_/B _445_/B _448_/B _547_/A1 VPWR VPWR VGND VGND gf180mcu_fd_sc_mcu7t5v0__oai211_1
X_376_ _390_/A1 _387_/A2 _430_/A3 _525_/B2 VPWR VPWR VGND VGND gf180mcu_fd_sc_mcu7t5v0__nor3_4
XPHY_EDGE_ROW_39_Left_82 VPWR VGND gf180mcu_fd_sc_mcu7t5v0__endcap
X_428_ _516_/A1 _428_/A2 _476_/B _438_/A3 _454_/A2 VPWR VPWR VGND VGND gf180mcu_fd_sc_mcu7t5v0__nand4_1
XPHY_EDGE_ROW_23_Left_66 VPWR VGND gf180mcu_fd_sc_mcu7t5v0__endcap
X_359_ _393_/A1 _364_/A1 _543_/B2 VPWR VPWR VGND VGND gf180mcu_fd_sc_mcu7t5v0__nor2_1
Xinput2 in input2/Z VPWR VPWR VGND VGND gf180mcu_fd_sc_mcu7t5v0__dlyb_1
XFILLER_21_22 VPWR VPWR VGND VGND gf180mcu_fd_sc_mcu7t5v0__fill_2
XFILLER_15_166 VPWR VPWR VGND VGND gf180mcu_fd_sc_mcu7t5v0__fillcap_32
XFILLER_16_33 VPWR VPWR VGND VGND gf180mcu_fd_sc_mcu7t5v0__fill_2
XFILLER_16_55 VPWR VPWR VGND VGND gf180mcu_fd_sc_mcu7t5v0__fill_2
XFILLER_8_107 VPWR VPWR VGND VGND gf180mcu_fd_sc_mcu7t5v0__fill_2
XPHY_EDGE_ROW_10_Left_53 VPWR VGND gf180mcu_fd_sc_mcu7t5v0__endcap
XFILLER_12_103 VPWR VPWR VGND VGND gf180mcu_fd_sc_mcu7t5v0__fill_2
XFILLER_8_129 VPWR VPWR VGND VGND gf180mcu_fd_sc_mcu7t5v0__fill_2
X_461_ _461_/A1 _444_/Z _461_/A3 T[3] VPWR VPWR VGND VGND gf180mcu_fd_sc_mcu7t5v0__and3_4
X_530_ _530_/A1 _556_/A2 _530_/A3 _530_/A4 _534_/A1 VPWR VPWR VGND VGND gf180mcu_fd_sc_mcu7t5v0__nand4_1
X_392_ _393_/A1 _377_/C _535_/B VPWR VPWR VGND VGND gf180mcu_fd_sc_mcu7t5v0__nor2_1
Xfanout46 _344_/Z _381_/A2 VPWR VPWR VGND VGND gf180mcu_fd_sc_mcu7t5v0__clkbuf_4
Xfanout57 _639_/Q _584_/A1 VPWR VPWR VGND VGND gf180mcu_fd_sc_mcu7t5v0__buf_4
Xfanout24 _420_/Z _512_/B VPWR VPWR VGND VGND gf180mcu_fd_sc_mcu7t5v0__buf_3
XFILLER_13_89 VPWR VPWR VGND VGND gf180mcu_fd_sc_mcu7t5v0__fill_2
X_444_ _457_/A1 _444_/A2 _444_/A3 _444_/Z VPWR VPWR VGND VGND gf180mcu_fd_sc_mcu7t5v0__or3_2
X_375_ _377_/C _487_/A2 VPWR VPWR VGND VGND gf180mcu_fd_sc_mcu7t5v0__clkinv_1
X_513_ _536_/A4 _513_/A2 _468_/B _535_/A1 _514_/A2 VPWR VPWR VGND VGND gf180mcu_fd_sc_mcu7t5v0__oai22_1
X_427_ _536_/A3 _501_/A4 _524_/A2 VPWR VPWR VGND VGND gf180mcu_fd_sc_mcu7t5v0__nor2_1
XFILLER_6_2 VPWR VPWR VGND VGND gf180mcu_fd_sc_mcu7t5v0__fillcap_32
X_358_ _390_/A1 _430_/A2 _364_/A1 VPWR VPWR VGND VGND gf180mcu_fd_sc_mcu7t5v0__nand2_1
Xinput3 rst_n input3/Z VPWR VPWR VGND VGND gf180mcu_fd_sc_mcu7t5v0__dlyb_1
XPHY_EDGE_ROW_27_Right_27 VPWR VGND gf180mcu_fd_sc_mcu7t5v0__endcap
XPHY_EDGE_ROW_18_Right_18 VPWR VGND gf180mcu_fd_sc_mcu7t5v0__endcap
XTAP_TAPCELL_ROW_1_91 VPWR VGND gf180mcu_fd_sc_mcu7t5v0__filltie
XFILLER_42_167 VPWR VPWR VGND VGND gf180mcu_fd_sc_mcu7t5v0__fill_2
XFILLER_42_134 VPWR VPWR VGND VGND gf180mcu_fd_sc_mcu7t5v0__fill_2
XPHY_EDGE_ROW_40_Left_83 VPWR VGND gf180mcu_fd_sc_mcu7t5v0__endcap
XTAP_TAPCELL_ROW_37_181 VPWR VGND gf180mcu_fd_sc_mcu7t5v0__filltie
XPHY_EDGE_ROW_36_Right_36 VPWR VGND gf180mcu_fd_sc_mcu7t5v0__endcap
XFILLER_10_79 VPWR VPWR VGND VGND gf180mcu_fd_sc_mcu7t5v0__fillcap_8
XTAP_TAPCELL_ROW_34_173 VPWR VGND gf180mcu_fd_sc_mcu7t5v0__filltie
Xmax_cap10 _462_/A1 _463_/A1 VPWR VPWR VGND VGND gf180mcu_fd_sc_mcu7t5v0__buf_4
XTAP_TAPCELL_ROW_25_151 VPWR VGND gf180mcu_fd_sc_mcu7t5v0__filltie
Xmax_cap54 _450_/B2 _508_/B2 VPWR VPWR VGND VGND gf180mcu_fd_sc_mcu7t5v0__clkbuf_2
XTAP_TAPCELL_ROW_8_108 VPWR VGND gf180mcu_fd_sc_mcu7t5v0__filltie
XTAP_TAPCELL_ROW_22_143 VPWR VGND gf180mcu_fd_sc_mcu7t5v0__filltie
XPHY_EDGE_ROW_0_Right_0 VPWR VGND gf180mcu_fd_sc_mcu7t5v0__endcap
XFILLER_21_2 VPWR VPWR VGND VGND gf180mcu_fd_sc_mcu7t5v0__fillcap_4
XFILLER_7_174 VPWR VPWR VGND VGND gf180mcu_fd_sc_mcu7t5v0__fillcap_16
XTAP_TAPCELL_ROW_13_121 VPWR VGND gf180mcu_fd_sc_mcu7t5v0__filltie
X_460_ _460_/A1 _444_/Z _461_/A3 wire6/I VPWR VPWR VGND VGND gf180mcu_fd_sc_mcu7t5v0__nor3_4
X_391_ _391_/A1 _396_/A3 _391_/A3 _516_/A2 VPWR VPWR VGND VGND gf180mcu_fd_sc_mcu7t5v0__nand3_1
XTAP_TAPCELL_ROW_4_100 VPWR VGND gf180mcu_fd_sc_mcu7t5v0__filltie
XTAP_TAPCELL_ROW_10_113 VPWR VGND gf180mcu_fd_sc_mcu7t5v0__filltie
X_589_ _589_/A1 _584_/Z _641_/Q _640_/Q _601_/A2 VPWR VPWR VGND VGND gf180mcu_fd_sc_mcu7t5v0__aoi211_2
XFILLER_4_199 VPWR VPWR VGND VGND gf180mcu_fd_sc_mcu7t5v0__fill_1
XFILLER_4_177 VPWR VPWR VGND VGND gf180mcu_fd_sc_mcu7t5v0__fillcap_16
XFILLER_4_37 VPWR VPWR VGND VGND gf180mcu_fd_sc_mcu7t5v0__fillcap_64
Xfanout58 _638_/Q _584_/A2 VPWR VPWR VGND VGND gf180mcu_fd_sc_mcu7t5v0__buf_4
Xfanout47 _342_/Z _348_/A1 VPWR VPWR VGND VGND gf180mcu_fd_sc_mcu7t5v0__clkbuf_4
Xfanout25 _420_/Z _448_/B VPWR VPWR VGND VGND gf180mcu_fd_sc_mcu7t5v0__buf_1
XFILLER_1_136 VPWR VPWR VGND VGND gf180mcu_fd_sc_mcu7t5v0__fillcap_4
XFILLER_13_24 VPWR VPWR VGND VGND gf180mcu_fd_sc_mcu7t5v0__fillcap_4
X_443_ _457_/A1 _444_/A2 _444_/A3 _463_/A2 VPWR VPWR VGND VGND gf180mcu_fd_sc_mcu7t5v0__nor3_4
X_374_ _430_/A1 _391_/A3 _377_/C VPWR VPWR VGND VGND gf180mcu_fd_sc_mcu7t5v0__nand2_2
X_512_ _525_/B2 _397_/Z _512_/B _514_/A1 VPWR VPWR VGND VGND gf180mcu_fd_sc_mcu7t5v0__oai21_1
XFILLER_40_77 VPWR VPWR VGND VGND gf180mcu_fd_sc_mcu7t5v0__fill_1
XFILLER_36_198 VPWR VPWR VGND VGND gf180mcu_fd_sc_mcu7t5v0__fill_2
X_357_ _483_/A2 _387_/A2 _445_/B VPWR VPWR VGND VGND gf180mcu_fd_sc_mcu7t5v0__nor2_2
X_426_ _476_/B _438_/A3 _546_/A2 VPWR VPWR VGND VGND gf180mcu_fd_sc_mcu7t5v0__nand2_1
Xclkbuf_2_1__f_clk clkbuf_0_clk/Z _646_/CLK VPWR VPWR VGND VGND gf180mcu_fd_sc_mcu7t5v0__clkbuf_16
XTAP_TAPCELL_ROW_1_92 VPWR VGND gf180mcu_fd_sc_mcu7t5v0__filltie
XTAP_TAPCELL_ROW_37_182 VPWR VGND gf180mcu_fd_sc_mcu7t5v0__filltie
XFILLER_33_113 VPWR VPWR VGND VGND gf180mcu_fd_sc_mcu7t5v0__fill_1
XTAP_TAPCELL_ROW_28_160 VPWR VGND gf180mcu_fd_sc_mcu7t5v0__filltie
X_409_ _415_/A1 _410_/B _544_/B VPWR VPWR VGND VGND gf180mcu_fd_sc_mcu7t5v0__nor2_1
XTAP_TAPCELL_ROW_34_174 VPWR VGND gf180mcu_fd_sc_mcu7t5v0__filltie
XFILLER_21_24 VPWR VPWR VGND VGND gf180mcu_fd_sc_mcu7t5v0__fill_1
XTAP_TAPCELL_ROW_40_188 VPWR VGND gf180mcu_fd_sc_mcu7t5v0__filltie
XTAP_TAPCELL_ROW_25_152 VPWR VGND gf180mcu_fd_sc_mcu7t5v0__filltie
XTAP_TAPCELL_ROW_31_166 VPWR VGND gf180mcu_fd_sc_mcu7t5v0__filltie
XTAP_TAPCELL_ROW_16_130 VPWR VGND gf180mcu_fd_sc_mcu7t5v0__filltie
XTAP_TAPCELL_ROW_8_109 VPWR VGND gf180mcu_fd_sc_mcu7t5v0__filltie
XTAP_TAPCELL_ROW_22_144 VPWR VGND gf180mcu_fd_sc_mcu7t5v0__filltie
XFILLER_20_193 VPWR VPWR VGND VGND gf180mcu_fd_sc_mcu7t5v0__fillcap_4
XFILLER_20_171 VPWR VPWR VGND VGND gf180mcu_fd_sc_mcu7t5v0__fillcap_4
XFILLER_16_57 VPWR VPWR VGND VGND gf180mcu_fd_sc_mcu7t5v0__fill_1
XFILLER_8_109 VPWR VPWR VGND VGND gf180mcu_fd_sc_mcu7t5v0__fill_1
XFILLER_12_116 VPWR VPWR VGND VGND gf180mcu_fd_sc_mcu7t5v0__fillcap_4
XFILLER_7_142 VPWR VPWR VGND VGND gf180mcu_fd_sc_mcu7t5v0__fillcap_32
XTAP_TAPCELL_ROW_13_122 VPWR VGND gf180mcu_fd_sc_mcu7t5v0__filltie
XFILLER_14_2 VPWR VPWR VGND VGND gf180mcu_fd_sc_mcu7t5v0__fill_2
X_390_ _390_/A1 _430_/A2 _430_/A3 _517_/A2 VPWR VPWR VGND VGND gf180mcu_fd_sc_mcu7t5v0__nor3_2
X_588_ _640_/Q _596_/A1 _648_/Q _640_/D VPWR VPWR VGND VGND gf180mcu_fd_sc_mcu7t5v0__mux2_2
XFILLER_4_101 VPWR VPWR VGND VGND gf180mcu_fd_sc_mcu7t5v0__fillcap_4
XTAP_TAPCELL_ROW_10_114 VPWR VGND gf180mcu_fd_sc_mcu7t5v0__filltie
Xfanout59 _638_/Q _582_/A1 VPWR VPWR VGND VGND gf180mcu_fd_sc_mcu7t5v0__buf_2
Xfanout48 _342_/Z _395_/A3 VPWR VPWR VGND VGND gf180mcu_fd_sc_mcu7t5v0__buf_3
Xfanout15 _543_/C1 _468_/B VPWR VPWR VGND VGND gf180mcu_fd_sc_mcu7t5v0__buf_1
Xfanout26 _414_/ZN _507_/B VPWR VPWR VGND VGND gf180mcu_fd_sc_mcu7t5v0__buf_4
X_442_ _455_/A1 _545_/A1 _442_/A3 _442_/A4 _444_/A3 VPWR VPWR VGND VGND gf180mcu_fd_sc_mcu7t5v0__nand4_1
X_373_ _339_/Z _396_/A3 _430_/A2 _484_/A1 VPWR VPWR VGND VGND gf180mcu_fd_sc_mcu7t5v0__nand3_2
X_511_ _511_/A1 _511_/A2 _511_/A3 _522_/A2 VPWR VPWR VGND VGND gf180mcu_fd_sc_mcu7t5v0__nand3_1
X_356_ _487_/A1 _355_/Z _530_/A1 VPWR VPWR VGND VGND gf180mcu_fd_sc_mcu7t5v0__nand2_1
X_425_ _347_/B _483_/A1 _425_/A3 _344_/Z _438_/A3 VPWR VPWR VGND VGND gf180mcu_fd_sc_mcu7t5v0__nand4_1
XFILLER_19_57 VPWR VPWR VGND VGND gf180mcu_fd_sc_mcu7t5v0__fill_2
XFILLER_10_37 VPWR VPWR VGND VGND gf180mcu_fd_sc_mcu7t5v0__fillcap_4
XFILLER_42_169 VPWR VPWR VGND VGND gf180mcu_fd_sc_mcu7t5v0__fill_1
X_408_ _352_/Z _536_/A4 _410_/A2 VPWR VPWR VGND VGND gf180mcu_fd_sc_mcu7t5v0__nor2_1
XTAP_TAPCELL_ROW_34_175 VPWR VGND gf180mcu_fd_sc_mcu7t5v0__filltie
X_339_ _584_/A2 _339_/A2 _339_/Z VPWR VPWR VGND VGND gf180mcu_fd_sc_mcu7t5v0__xor2_2
XTAP_TAPCELL_ROW_40_189 VPWR VGND gf180mcu_fd_sc_mcu7t5v0__filltie
XFILLER_21_69 VPWR VPWR VGND VGND gf180mcu_fd_sc_mcu7t5v0__fill_1
XTAP_TAPCELL_ROW_31_167 VPWR VGND gf180mcu_fd_sc_mcu7t5v0__filltie
XTAP_TAPCELL_ROW_22_145 VPWR VGND gf180mcu_fd_sc_mcu7t5v0__filltie
XFILLER_7_198 VPWR VPWR VGND VGND gf180mcu_fd_sc_mcu7t5v0__fill_2
XFILLER_11_172 VPWR VPWR VGND VGND gf180mcu_fd_sc_mcu7t5v0__fillcap_16
XFILLER_11_161 VPWR VPWR VGND VGND gf180mcu_fd_sc_mcu7t5v0__fill_1
XPHY_EDGE_ROW_14_Left_57 VPWR VGND gf180mcu_fd_sc_mcu7t5v0__endcap
X_587_ _593_/A3 _586_/Z _596_/A1 VPWR VPWR VGND VGND gf180mcu_fd_sc_mcu7t5v0__nor2_1
XTAP_TAPCELL_ROW_10_115 VPWR VGND gf180mcu_fd_sc_mcu7t5v0__filltie
Xfanout49 _341_/ZN _393_/C VPWR VPWR VGND VGND gf180mcu_fd_sc_mcu7t5v0__buf_8
XFILLER_3_190 VPWR VPWR VGND VGND gf180mcu_fd_sc_mcu7t5v0__fillcap_8
XFILLER_38_67 VPWR VPWR VGND VGND gf180mcu_fd_sc_mcu7t5v0__fill_2
X_441_ _441_/A1 _520_/B2 _432_/B _510_/B _442_/A4 VPWR VPWR VGND VGND gf180mcu_fd_sc_mcu7t5v0__oai31_1
X_372_ _528_/B2 _355_/Z _519_/A2 _482_/B _556_/A1 VPWR VPWR VGND VGND gf180mcu_fd_sc_mcu7t5v0__oai31_4
X_510_ _382_/Z _510_/A2 _513_/A2 _510_/B _511_/A3 VPWR VPWR VGND VGND gf180mcu_fd_sc_mcu7t5v0__oai31_1
XFILLER_13_48 VPWR VPWR VGND VGND gf180mcu_fd_sc_mcu7t5v0__fill_1
X_639_ _639_/D _639_/RN _642_/CLK _639_/Q VPWR VPWR VGND VGND gf180mcu_fd_sc_mcu7t5v0__dffrnq_2
XFILLER_39_164 VPWR VPWR VGND VGND gf180mcu_fd_sc_mcu7t5v0__fill_2
XFILLER_39_142 VPWR VPWR VGND VGND gf180mcu_fd_sc_mcu7t5v0__fill_1
XFILLER_24_58 VPWR VPWR VGND VGND gf180mcu_fd_sc_mcu7t5v0__fill_2
XPHY_EDGE_ROW_17_Left_60 VPWR VGND gf180mcu_fd_sc_mcu7t5v0__endcap
X_424_ _483_/A2 _424_/A2 _350_/Z _501_/A4 VPWR VPWR VGND VGND gf180mcu_fd_sc_mcu7t5v0__nor3_4
X_355_ _551_/A1 _507_/A1 _355_/Z VPWR VPWR VGND VGND gf180mcu_fd_sc_mcu7t5v0__or2_2
XFILLER_42_104 VPWR VPWR VGND VGND gf180mcu_fd_sc_mcu7t5v0__fillcap_4
XPHY_EDGE_ROW_23_Right_23 VPWR VGND gf180mcu_fd_sc_mcu7t5v0__endcap
XFILLER_4_2 VPWR VPWR VGND VGND gf180mcu_fd_sc_mcu7t5v0__fillcap_32
XPHY_EDGE_ROW_2_Left_45 VPWR VGND gf180mcu_fd_sc_mcu7t5v0__endcap
XPHY_EDGE_ROW_14_Right_14 VPWR VGND gf180mcu_fd_sc_mcu7t5v0__endcap
X_338_ _347_/B _337_/Z _338_/B _483_/A1 VPWR VPWR VGND VGND gf180mcu_fd_sc_mcu7t5v0__aoi21_2
XPHY_EDGE_ROW_41_Right_41 VPWR VGND gf180mcu_fd_sc_mcu7t5v0__endcap
XFILLER_37_2 VPWR VPWR VGND VGND gf180mcu_fd_sc_mcu7t5v0__fill_1
XPHY_EDGE_ROW_32_Right_32 VPWR VGND gf180mcu_fd_sc_mcu7t5v0__endcap
X_407_ _535_/A1 _451_/A2 _407_/Z VPWR VPWR VGND VGND gf180mcu_fd_sc_mcu7t5v0__and2_1
XFILLER_15_148 VPWR VPWR VGND VGND gf180mcu_fd_sc_mcu7t5v0__fill_2
Xmax_cap13 _459_/A1 _461_/A1 VPWR VPWR VGND VGND gf180mcu_fd_sc_mcu7t5v0__buf_2
XFILLER_14_170 VPWR VPWR VGND VGND gf180mcu_fd_sc_mcu7t5v0__fillcap_4
XFILLER_7_122 VPWR VPWR VGND VGND gf180mcu_fd_sc_mcu7t5v0__fillcap_16
XPHY_EDGE_ROW_4_Right_4 VPWR VGND gf180mcu_fd_sc_mcu7t5v0__endcap
XFILLER_14_4 VPWR VPWR VGND VGND gf180mcu_fd_sc_mcu7t5v0__fill_1
XPHY_EDGE_ROW_31_Left_74 VPWR VGND gf180mcu_fd_sc_mcu7t5v0__endcap
X_586_ _640_/Q _589_/A1 _584_/Z _586_/Z VPWR VPWR VGND VGND gf180mcu_fd_sc_mcu7t5v0__and3_1
X_371_ _406_/B _476_/B _519_/A2 VPWR VPWR VGND VGND gf180mcu_fd_sc_mcu7t5v0__nand2_1
X_440_ _441_/A1 _541_/B _502_/B _442_/A3 VPWR VPWR VGND VGND gf180mcu_fd_sc_mcu7t5v0__aoi21_1
X_638_ _638_/D _639_/RN _647_/CLK _638_/Q VPWR VPWR VGND VGND gf180mcu_fd_sc_mcu7t5v0__dffrnq_2
X_569_ _634_/Q _570_/A2 _571_/A2 VPWR VPWR VGND VGND gf180mcu_fd_sc_mcu7t5v0__nand2_1
XFILLER_0_172 VPWR VPWR VGND VGND gf180mcu_fd_sc_mcu7t5v0__fillcap_16
XFILLER_24_37 VPWR VPWR VGND VGND gf180mcu_fd_sc_mcu7t5v0__fill_2
XFILLER_5_72 VPWR VPWR VGND VGND gf180mcu_fd_sc_mcu7t5v0__fillcap_64
X_354_ _393_/C _387_/A2 _350_/Z _354_/B _482_/A1 VPWR VPWR VGND VGND gf180mcu_fd_sc_mcu7t5v0__oai31_4
X_423_ _416_/Z _448_/B _433_/A4 VPWR VPWR VGND VGND gf180mcu_fd_sc_mcu7t5v0__nand2_1
XFILLER_19_48 VPWR VPWR VGND VGND gf180mcu_fd_sc_mcu7t5v0__fill_1
X_406_ _483_/A2 _406_/A2 _406_/B _476_/B _451_/A2 VPWR VPWR VGND VGND gf180mcu_fd_sc_mcu7t5v0__oai211_1
X_337_ _336_/B _644_/Q _337_/Z VPWR VPWR VGND VGND gf180mcu_fd_sc_mcu7t5v0__and2_2
XFILLER_18_157 VPWR VPWR VGND VGND gf180mcu_fd_sc_mcu7t5v0__fill_1
XFILLER_14_193 VPWR VPWR VGND VGND gf180mcu_fd_sc_mcu7t5v0__fillcap_4
XFILLER_11_196 VPWR VPWR VGND VGND gf180mcu_fd_sc_mcu7t5v0__fillcap_4
X_585_ _589_/A1 _584_/Z _640_/Q _593_/A3 VPWR VPWR VGND VGND gf180mcu_fd_sc_mcu7t5v0__aoi21_1
XFILLER_38_69 VPWR VPWR VGND VGND gf180mcu_fd_sc_mcu7t5v0__fill_1
Xfanout29 _414_/ZN _451_/B1 VPWR VPWR VGND VGND gf180mcu_fd_sc_mcu7t5v0__buf_1
XFILLER_12_2 VPWR VPWR VGND VGND gf180mcu_fd_sc_mcu7t5v0__fillcap_4
XFILLER_13_17 VPWR VPWR VGND VGND gf180mcu_fd_sc_mcu7t5v0__fill_2
X_637_ _637_/D _639_/RN _647_/CLK _637_/Q VPWR VPWR VGND VGND gf180mcu_fd_sc_mcu7t5v0__dffrnq_2
X_370_ _396_/A1 _396_/A2 _393_/C _476_/B VPWR VPWR VGND VGND gf180mcu_fd_sc_mcu7t5v0__nand3_2
XFILLER_28_91 VPWR VPWR VGND VGND gf180mcu_fd_sc_mcu7t5v0__fill_1
X_568_ _625_/A1 _579_/A1 _570_/A2 VPWR VPWR VGND VGND gf180mcu_fd_sc_mcu7t5v0__nor2_1
X_499_ _552_/A1 _499_/A2 _499_/Z VPWR VPWR VGND VGND gf180mcu_fd_sc_mcu7t5v0__and2_1
X_353_ _640_/Q _501_/A1 _354_/B VPWR VPWR VGND VGND gf180mcu_fd_sc_mcu7t5v0__nand2_1
X_422_ _508_/A1 _507_/B _512_/B _465_/B2 _503_/A1 VPWR VPWR VGND VGND gf180mcu_fd_sc_mcu7t5v0__aoi22_1
XFILLER_10_18 VPWR VPWR VGND VGND gf180mcu_fd_sc_mcu7t5v0__fill_1
X_336_ _347_/B _330_/B _336_/B _338_/B VPWR VPWR VGND VGND gf180mcu_fd_sc_mcu7t5v0__aoi21_2
X_405_ _398_/Z _502_/B _405_/Z VPWR VPWR VGND VGND gf180mcu_fd_sc_mcu7t5v0__and2_4
XFILLER_18_169 VPWR VPWR VGND VGND gf180mcu_fd_sc_mcu7t5v0__fill_1
XFILLER_11_72 VPWR VPWR VGND VGND gf180mcu_fd_sc_mcu7t5v0__fill_2
Xmax_cap37 _520_/A1 _487_/A1 VPWR VPWR VGND VGND gf180mcu_fd_sc_mcu7t5v0__buf_4
XFILLER_42_2 VPWR VPWR VGND VGND gf180mcu_fd_sc_mcu7t5v0__fill_2
X_319_ _641_/Q _330_/B _331_/B VPWR VPWR VGND VGND gf180mcu_fd_sc_mcu7t5v0__nand2_1
XFILLER_20_197 VPWR VPWR VGND VGND gf180mcu_fd_sc_mcu7t5v0__fill_2
XFILLER_11_142 VPWR VPWR VGND VGND gf180mcu_fd_sc_mcu7t5v0__fill_1
X_584_ _584_/A1 _584_/A2 _584_/Z VPWR VPWR VGND VGND gf180mcu_fd_sc_mcu7t5v0__and2_1
XFILLER_38_37 VPWR VPWR VGND VGND gf180mcu_fd_sc_mcu7t5v0__fillcap_4
XFILLER_0_196 VPWR VPWR VGND VGND gf180mcu_fd_sc_mcu7t5v0__fillcap_4
X_636_ _636_/D _639_/RN _647_/CLK _636_/Q VPWR VPWR VGND VGND gf180mcu_fd_sc_mcu7t5v0__dffrnq_1
X_567_ _633_/Q _567_/A2 _633_/D VPWR VPWR VGND VGND gf180mcu_fd_sc_mcu7t5v0__xor2_1
X_498_ _488_/Z _498_/A2 _498_/A3 B[0] VPWR VPWR VGND VGND gf180mcu_fd_sc_mcu7t5v0__nand3_4
XFILLER_24_39 VPWR VPWR VGND VGND gf180mcu_fd_sc_mcu7t5v0__fill_1
X_421_ _508_/A1 _465_/A2 _552_/A3 VPWR VPWR VGND VGND gf180mcu_fd_sc_mcu7t5v0__nand2_1
X_352_ _640_/Q _501_/A1 _352_/Z VPWR VPWR VGND VGND gf180mcu_fd_sc_mcu7t5v0__and2_1
X_619_ _591_/Z _619_/A2 _619_/B _619_/C _623_/A1 VPWR VPWR VGND VGND gf180mcu_fd_sc_mcu7t5v0__oai211_1
X_335_ _391_/A1 _330_/B _339_/A2 VPWR VPWR VGND VGND gf180mcu_fd_sc_mcu7t5v0__nand2_1
XFILLER_18_115 VPWR VPWR VGND VGND gf180mcu_fd_sc_mcu7t5v0__fill_2
X_404_ _318_/Z _410_/B _404_/B _544_/C VPWR VPWR VGND VGND gf180mcu_fd_sc_mcu7t5v0__oai21_1
XPHY_EDGE_ROW_10_Right_10 VPWR VGND gf180mcu_fd_sc_mcu7t5v0__endcap
XPHY_EDGE_ROW_6_Left_49 VPWR VGND gf180mcu_fd_sc_mcu7t5v0__endcap
XFILLER_2_2 VPWR VPWR VGND VGND gf180mcu_fd_sc_mcu7t5v0__fillcap_32
XFILLER_15_107 VPWR VPWR VGND VGND gf180mcu_fd_sc_mcu7t5v0__fill_2
X_318_ _640_/Q _477_/A1 _584_/A2 _584_/A1 _318_/Z VPWR VPWR VGND VGND gf180mcu_fd_sc_mcu7t5v0__or4_4
XFILLER_22_72 VPWR VPWR VGND VGND gf180mcu_fd_sc_mcu7t5v0__fill_1
X_583_ _639_/Q _583_/A2 _639_/D VPWR VPWR VGND VGND gf180mcu_fd_sc_mcu7t5v0__xnor2_1
XPHY_EDGE_ROW_9_Left_52 VPWR VGND gf180mcu_fd_sc_mcu7t5v0__endcap
XPHY_EDGE_ROW_8_Right_8 VPWR VGND gf180mcu_fd_sc_mcu7t5v0__endcap
XPHY_EDGE_ROW_39_Right_39 VPWR VGND gf180mcu_fd_sc_mcu7t5v0__endcap
XPHY_EDGE_ROW_35_Left_78 VPWR VGND gf180mcu_fd_sc_mcu7t5v0__endcap
X_635_ _635_/D _639_/RN _648_/CLK _635_/Q VPWR VPWR VGND VGND gf180mcu_fd_sc_mcu7t5v0__dffrnq_1
X_566_ _630_/Q _631_/Q _632_/Q _633_/Q _579_/A1 VPWR VPWR VGND VGND gf180mcu_fd_sc_mcu7t5v0__aoi211_4
X_497_ _386_/Z _544_/B _497_/A3 _497_/A4 _498_/A3 VPWR VPWR VGND VGND gf180mcu_fd_sc_mcu7t5v0__nor4_4
X_351_ _577_/A1 _415_/A1 _495_/A1 VPWR VPWR VGND VGND gf180mcu_fd_sc_mcu7t5v0__nor2_2
X_420_ _420_/A1 _515_/A3 _420_/Z VPWR VPWR VGND VGND gf180mcu_fd_sc_mcu7t5v0__and2_1
XFILLER_35_28 VPWR VPWR VGND VGND gf180mcu_fd_sc_mcu7t5v0__fill_2
X_549_ _549_/A1 _549_/A2 _549_/A3 B[3] VPWR VPWR VGND VGND gf180mcu_fd_sc_mcu7t5v0__or3_2
X_618_ _618_/A1 _618_/A2 _618_/B _643_/D VPWR VPWR VGND VGND gf180mcu_fd_sc_mcu7t5v0__oai21_1
X_334_ _478_/C _377_/B2 _333_/Z _520_/A1 VPWR VPWR VGND VGND gf180mcu_fd_sc_mcu7t5v0__nor3_4
X_403_ _453_/A1 _520_/B2 _420_/A1 _404_/B VPWR VPWR VGND VGND gf180mcu_fd_sc_mcu7t5v0__nand3_1
XPHY_EDGE_ROW_38_Left_81 VPWR VGND gf180mcu_fd_sc_mcu7t5v0__endcap
XPHY_EDGE_ROW_22_Left_65 VPWR VGND gf180mcu_fd_sc_mcu7t5v0__endcap
Xmax_cap39 _491_/A1 _540_/B VPWR VPWR VGND VGND gf180mcu_fd_sc_mcu7t5v0__buf_4
X_317_ _640_/Q _477_/A1 _584_/A2 _584_/A1 _450_/B2 VPWR VPWR VGND VGND gf180mcu_fd_sc_mcu7t5v0__nor4_4
XFILLER_14_163 VPWR VPWR VGND VGND gf180mcu_fd_sc_mcu7t5v0__fill_2
XFILLER_14_174 VPWR VPWR VGND VGND gf180mcu_fd_sc_mcu7t5v0__fill_1
XFILLER_20_199 VPWR VPWR VGND VGND gf180mcu_fd_sc_mcu7t5v0__fill_1
Xclkbuf_2_2__f_clk clkbuf_0_clk/Z _647_/CLK VPWR VPWR VGND VGND gf180mcu_fd_sc_mcu7t5v0__clkbuf_16
XFILLER_11_133 VPWR VPWR VGND VGND gf180mcu_fd_sc_mcu7t5v0__fillcap_4
XFILLER_11_188 VPWR VPWR VGND VGND gf180mcu_fd_sc_mcu7t5v0__fillcap_8
XFILLER_27_18 VPWR VPWR VGND VGND gf180mcu_fd_sc_mcu7t5v0__fill_1
X_582_ _582_/A1 _582_/A2 _638_/D VPWR VPWR VGND VGND gf180mcu_fd_sc_mcu7t5v0__xnor2_1
XFILLER_4_107 VPWR VPWR VGND VGND gf180mcu_fd_sc_mcu7t5v0__fillcap_64
XFILLER_33_72 VPWR VPWR VGND VGND gf180mcu_fd_sc_mcu7t5v0__fill_2
XTAP_TAPCELL_ROW_4_98 VPWR VGND gf180mcu_fd_sc_mcu7t5v0__filltie
X_634_ _634_/D _639_/RN _642_/CLK _634_/Q VPWR VPWR VGND VGND gf180mcu_fd_sc_mcu7t5v0__dffrnq_1
X_565_ _632_/Q _565_/A2 _632_/D VPWR VPWR VGND VGND gf180mcu_fd_sc_mcu7t5v0__xnor2_1
X_496_ _496_/A1 _496_/A2 _496_/A3 _496_/A4 _497_/A4 VPWR VPWR VGND VGND gf180mcu_fd_sc_mcu7t5v0__nand4_1
XFILLER_10_2 VPWR VPWR VGND VGND gf180mcu_fd_sc_mcu7t5v0__fillcap_16
X_350_ _577_/A1 _338_/B _337_/Z _350_/Z VPWR VPWR VGND VGND gf180mcu_fd_sc_mcu7t5v0__or3_4
X_548_ _556_/A1 _548_/A2 _547_/Z _549_/A3 VPWR VPWR VGND VGND gf180mcu_fd_sc_mcu7t5v0__nand3_1
X_617_ _620_/B _617_/A2 _619_/C _617_/B _618_/A2 VPWR VPWR VGND VGND gf180mcu_fd_sc_mcu7t5v0__oai31_1
X_479_ _500_/B _501_/A4 _510_/B _511_/A1 VPWR VPWR VGND VGND gf180mcu_fd_sc_mcu7t5v0__oai21_1
Xrebuffer80 _411_/Z _444_/A2 VPWR VPWR VGND VGND gf180mcu_fd_sc_mcu7t5v0__buf_8
X_402_ _453_/A1 _476_/A1 _333_/Z _410_/B VPWR VPWR VGND VGND gf180mcu_fd_sc_mcu7t5v0__nand3_1
X_333_ _435_/A3 _435_/A4 _333_/Z VPWR VPWR VGND VGND gf180mcu_fd_sc_mcu7t5v0__and2_2
XFILLER_15_109 VPWR VPWR VGND VGND gf180mcu_fd_sc_mcu7t5v0__fill_1
X_316_ _584_/A1 _584_/A2 _391_/A1 _501_/A1 VPWR VPWR VGND VGND gf180mcu_fd_sc_mcu7t5v0__nor3_2
XFILLER_14_197 VPWR VPWR VGND VGND gf180mcu_fd_sc_mcu7t5v0__fill_2
XFILLER_9_190 VPWR VPWR VGND VGND gf180mcu_fd_sc_mcu7t5v0__fillcap_8
XFILLER_7_138 VPWR VPWR VGND VGND gf180mcu_fd_sc_mcu7t5v0__fill_2
XFILLER_40_2 VPWR VPWR VGND VGND gf180mcu_fd_sc_mcu7t5v0__fill_2
XFILLER_6_193 VPWR VPWR VGND VGND gf180mcu_fd_sc_mcu7t5v0__fillcap_4
XFILLER_6_171 VPWR VPWR VGND VGND gf180mcu_fd_sc_mcu7t5v0__fillcap_4
XFILLER_8_87 VPWR VPWR VGND VGND gf180mcu_fd_sc_mcu7t5v0__fill_1
X_581_ _582_/A1 _617_/B _589_/A1 _583_/A2 VPWR VPWR VGND VGND gf180mcu_fd_sc_mcu7t5v0__nand3_1
XTAP_TAPCELL_ROW_4_99 VPWR VGND gf180mcu_fd_sc_mcu7t5v0__filltie
XFILLER_3_174 VPWR VPWR VGND VGND gf180mcu_fd_sc_mcu7t5v0__fillcap_16
XFILLER_12_6 VPWR VPWR VGND VGND gf180mcu_fd_sc_mcu7t5v0__fill_2
X_633_ _633_/D _644_/RN _648_/CLK _633_/Q VPWR VPWR VGND VGND gf180mcu_fd_sc_mcu7t5v0__dffrnq_1
X_564_ _632_/Q _565_/A2 _567_/A2 VPWR VPWR VGND VGND gf180mcu_fd_sc_mcu7t5v0__nor2_1
X_495_ _495_/A1 _495_/A2 _495_/B _496_/A4 VPWR VPWR VGND VGND gf180mcu_fd_sc_mcu7t5v0__oai21_1
XFILLER_0_188 VPWR VPWR VGND VGND gf180mcu_fd_sc_mcu7t5v0__fillcap_8
XFILLER_5_66 VPWR VPWR VGND VGND gf180mcu_fd_sc_mcu7t5v0__fillcap_4
XFILLER_36_107 VPWR VPWR VGND VGND gf180mcu_fd_sc_mcu7t5v0__fillcap_4
X_547_ _547_/A1 _547_/A2 _547_/A3 _547_/A4 _547_/Z VPWR VPWR VGND VGND gf180mcu_fd_sc_mcu7t5v0__and4_1
X_478_ _516_/A2 _478_/A2 _478_/B _478_/C _532_/B VPWR VPWR VGND VGND gf180mcu_fd_sc_mcu7t5v0__aoi211_1
X_616_ _616_/A1 _616_/A2 _616_/B _618_/A1 VPWR VPWR VGND VGND gf180mcu_fd_sc_mcu7t5v0__aoi21_1
Xrebuffer70 _584_/A1 _396_/A1 VPWR VPWR VGND VGND gf180mcu_fd_sc_mcu7t5v0__buf_8
XFILLER_2_34 VPWR VPWR VGND VGND gf180mcu_fd_sc_mcu7t5v0__fill_1
X_401_ _478_/C _414_/A1 _515_/A1 _401_/ZN VPWR VPWR VGND VGND gf180mcu_fd_sc_mcu7t5v0__nor3_2
X_332_ _435_/A3 _435_/A4 _515_/A1 VPWR VPWR VGND VGND gf180mcu_fd_sc_mcu7t5v0__nand2_2
XTAP_TAPCELL_ROW_42_193 VPWR VGND gf180mcu_fd_sc_mcu7t5v0__filltie
XFILLER_32_198 VPWR VPWR VGND VGND gf180mcu_fd_sc_mcu7t5v0__fill_2
XTAP_TAPCELL_ROW_33_171 VPWR VGND gf180mcu_fd_sc_mcu7t5v0__filltie
X_315_ _336_/B _347_/B _396_/A2 VPWR VPWR VGND VGND gf180mcu_fd_sc_mcu7t5v0__nor2_2
XTAP_TAPCELL_ROW_30_163 VPWR VGND gf180mcu_fd_sc_mcu7t5v0__filltie
XTAP_TAPCELL_ROW_21_141 VPWR VGND gf180mcu_fd_sc_mcu7t5v0__filltie
XTAP_TAPCELL_ROW_7_106 VPWR VGND gf180mcu_fd_sc_mcu7t5v0__filltie
XFILLER_0_2 VPWR VPWR VGND VGND gf180mcu_fd_sc_mcu7t5v0__fillcap_32
XFILLER_8_66 VPWR VPWR VGND VGND gf180mcu_fd_sc_mcu7t5v0__fillcap_4
X_580_ _617_/B _589_/A1 _582_/A2 VPWR VPWR VGND VGND gf180mcu_fd_sc_mcu7t5v0__nand2_1
XFILLER_3_142 VPWR VPWR VGND VGND gf180mcu_fd_sc_mcu7t5v0__fillcap_32
X_632_ _632_/D _639_/RN _648_/CLK _632_/Q VPWR VPWR VGND VGND gf180mcu_fd_sc_mcu7t5v0__dffrnq_1
X_563_ _617_/B _563_/A2 _565_/A2 VPWR VPWR VGND VGND gf180mcu_fd_sc_mcu7t5v0__nand2_1
XPHY_EDGE_ROW_26_Right_26 VPWR VGND gf180mcu_fd_sc_mcu7t5v0__endcap
XPHY_EDGE_ROW_17_Right_17 VPWR VGND gf180mcu_fd_sc_mcu7t5v0__endcap
XPHY_EDGE_ROW_35_Right_35 VPWR VGND gf180mcu_fd_sc_mcu7t5v0__endcap
X_494_ _508_/A1 _508_/A2 _531_/C _496_/A3 VPWR VPWR VGND VGND gf180mcu_fd_sc_mcu7t5v0__aoi21_1
X_477_ _477_/A1 _445_/B _554_/B2 _496_/A1 VPWR VPWR VGND VGND gf180mcu_fd_sc_mcu7t5v0__nand3_1
X_546_ _546_/A1 _546_/A2 _546_/B _547_/A4 VPWR VPWR VGND VGND gf180mcu_fd_sc_mcu7t5v0__oai21_1
X_615_ _646_/Q _613_/Z _616_/B VPWR VPWR VGND VGND gf180mcu_fd_sc_mcu7t5v0__xor2_1
XTAP_TAPCELL_ROW_36_180 VPWR VGND gf180mcu_fd_sc_mcu7t5v0__filltie
Xrebuffer71 _584_/A2 _336_/B VPWR VPWR VGND VGND gf180mcu_fd_sc_mcu7t5v0__buf_8
X_400_ _556_/A1 _552_/A2 _556_/A2 _548_/A2 _434_/A4 VPWR VPWR VGND VGND gf180mcu_fd_sc_mcu7t5v0__nand4_4
XTAP_TAPCELL_ROW_28_158 VPWR VGND gf180mcu_fd_sc_mcu7t5v0__filltie
X_331_ _621_/A2 _331_/A2 _331_/B _331_/C _435_/A4 VPWR VPWR VGND VGND gf180mcu_fd_sc_mcu7t5v0__oai211_4
XTAP_TAPCELL_ROW_42_194 VPWR VGND gf180mcu_fd_sc_mcu7t5v0__filltie
XTAP_TAPCELL_ROW_19_136 VPWR VGND gf180mcu_fd_sc_mcu7t5v0__filltie
XFILLER_17_163 VPWR VPWR VGND VGND gf180mcu_fd_sc_mcu7t5v0__fill_1
X_529_ _499_/Z _529_/A2 _529_/A3 _542_/A2 _529_/Z VPWR VPWR VGND VGND gf180mcu_fd_sc_mcu7t5v0__and4_1
XTAP_TAPCELL_ROW_33_172 VPWR VGND gf180mcu_fd_sc_mcu7t5v0__filltie
XFILLER_11_66 VPWR VPWR VGND VGND gf180mcu_fd_sc_mcu7t5v0__fillcap_4
X_314_ _617_/B _625_/A1 VPWR VPWR VGND VGND gf180mcu_fd_sc_mcu7t5v0__clkinv_1
XPHY_EDGE_ROW_26_Left_69 VPWR VGND gf180mcu_fd_sc_mcu7t5v0__endcap
XTAP_TAPCELL_ROW_24_150 VPWR VGND gf180mcu_fd_sc_mcu7t5v0__filltie
XTAP_TAPCELL_ROW_16_128 VPWR VGND gf180mcu_fd_sc_mcu7t5v0__filltie
XFILLER_14_177 VPWR VPWR VGND VGND gf180mcu_fd_sc_mcu7t5v0__fillcap_16
XFILLER_14_199 VPWR VPWR VGND VGND gf180mcu_fd_sc_mcu7t5v0__fill_1
XTAP_TAPCELL_ROW_30_164 VPWR VGND gf180mcu_fd_sc_mcu7t5v0__filltie
XTAP_TAPCELL_ROW_7_107 VPWR VGND gf180mcu_fd_sc_mcu7t5v0__filltie
XTAP_TAPCELL_ROW_21_142 VPWR VGND gf180mcu_fd_sc_mcu7t5v0__filltie
XFILLER_8_34 VPWR VPWR VGND VGND gf180mcu_fd_sc_mcu7t5v0__fill_1
XFILLER_11_125 VPWR VPWR VGND VGND gf180mcu_fd_sc_mcu7t5v0__fillcap_4
XTAP_TAPCELL_ROW_12_120 VPWR VGND gf180mcu_fd_sc_mcu7t5v0__filltie
XPHY_EDGE_ROW_29_Left_72 VPWR VGND gf180mcu_fd_sc_mcu7t5v0__endcap
XFILLER_3_198 VPWR VPWR VGND VGND gf180mcu_fd_sc_mcu7t5v0__fill_2
XPHY_EDGE_ROW_13_Left_56 VPWR VGND gf180mcu_fd_sc_mcu7t5v0__endcap
X_493_ _493_/A1 _493_/A2 _493_/A3 _493_/A4 _497_/A3 VPWR VPWR VGND VGND gf180mcu_fd_sc_mcu7t5v0__nand4_1
X_562_ _631_/Q _562_/A2 _631_/D VPWR VPWR VGND VGND gf180mcu_fd_sc_mcu7t5v0__xnor2_1
X_631_ _631_/D _644_/RN _646_/CLK _631_/Q VPWR VPWR VGND VGND gf180mcu_fd_sc_mcu7t5v0__dffrnq_1
X_476_ _476_/A1 _406_/B _476_/B _495_/A2 VPWR VPWR VGND VGND gf180mcu_fd_sc_mcu7t5v0__oai21_1
XFILLER_30_32 VPWR VPWR VGND VGND gf180mcu_fd_sc_mcu7t5v0__fill_2
X_545_ _545_/A1 _545_/A2 _545_/A3 _545_/A4 _549_/A2 VPWR VPWR VGND VGND gf180mcu_fd_sc_mcu7t5v0__nand4_1
X_614_ _620_/A1 _643_/Q _614_/A3 _619_/C VPWR VPWR VGND VGND gf180mcu_fd_sc_mcu7t5v0__xor3_1
Xrebuffer72 _343_/A2 _347_/B VPWR VPWR VGND VGND gf180mcu_fd_sc_mcu7t5v0__buf_8
XTAP_TAPCELL_ROW_28_159 VPWR VGND gf180mcu_fd_sc_mcu7t5v0__filltie
X_330_ _641_/Q _318_/Z _330_/B _642_/Q _435_/A3 VPWR VPWR VGND VGND gf180mcu_fd_sc_mcu7t5v0__oai211_2
XTAP_TAPCELL_ROW_42_195 VPWR VGND gf180mcu_fd_sc_mcu7t5v0__filltie
X_459_ _459_/A1 _444_/Z _457_/Z wire7/I VPWR VPWR VGND VGND gf180mcu_fd_sc_mcu7t5v0__nor3_4
XFILLER_32_101 VPWR VPWR VGND VGND gf180mcu_fd_sc_mcu7t5v0__fillcap_4
X_528_ _369_/Z _448_/B _543_/C1 _528_/B2 _542_/A2 VPWR VPWR VGND VGND gf180mcu_fd_sc_mcu7t5v0__aoi22_1
XTAP_TAPCELL_ROW_19_137 VPWR VGND gf180mcu_fd_sc_mcu7t5v0__filltie
XTAP_TAPCELL_ROW_16_129 VPWR VGND gf180mcu_fd_sc_mcu7t5v0__filltie
XPHY_EDGE_ROW_1_Left_44 VPWR VGND gf180mcu_fd_sc_mcu7t5v0__endcap
X_313_ _330_/B _621_/A2 VPWR VPWR VGND VGND gf180mcu_fd_sc_mcu7t5v0__inv_1
XFILLER_14_101 VPWR VPWR VGND VGND gf180mcu_fd_sc_mcu7t5v0__fillcap_4
XTAP_TAPCELL_ROW_30_165 VPWR VGND gf180mcu_fd_sc_mcu7t5v0__filltie
XFILLER_11_148 VPWR VPWR VGND VGND gf180mcu_fd_sc_mcu7t5v0__fill_1
XFILLER_11_137 VPWR VPWR VGND VGND gf180mcu_fd_sc_mcu7t5v0__fill_2
XFILLER_19_2 VPWR VPWR VGND VGND gf180mcu_fd_sc_mcu7t5v0__fill_2
XFILLER_10_170 VPWR VPWR VGND VGND gf180mcu_fd_sc_mcu7t5v0__fillcap_4
XFILLER_17_66 VPWR VPWR VGND VGND gf180mcu_fd_sc_mcu7t5v0__fillcap_4
XPHY_EDGE_ROW_3_Right_3 VPWR VGND gf180mcu_fd_sc_mcu7t5v0__endcap
X_492_ _492_/A1 _502_/B _501_/A4 _554_/B2 _493_/A4 VPWR VPWR VGND VGND gf180mcu_fd_sc_mcu7t5v0__aoi22_1
X_561_ _630_/Q _631_/Q _563_/A2 VPWR VPWR VGND VGND gf180mcu_fd_sc_mcu7t5v0__nand2_1
XPHY_EDGE_ROW_30_Left_73 VPWR VGND gf180mcu_fd_sc_mcu7t5v0__endcap
X_630_ _630_/D _644_/RN _642_/CLK _630_/Q VPWR VPWR VGND VGND gf180mcu_fd_sc_mcu7t5v0__dffrnq_1
XFILLER_38_140 VPWR VPWR VGND VGND gf180mcu_fd_sc_mcu7t5v0__fill_1
XFILLER_30_22 VPWR VPWR VGND VGND gf180mcu_fd_sc_mcu7t5v0__fill_1
X_613_ _643_/Q _614_/A3 _613_/Z VPWR VPWR VGND VGND gf180mcu_fd_sc_mcu7t5v0__xor2_1
X_544_ _535_/B _505_/B _544_/B _544_/C _545_/A4 VPWR VPWR VGND VGND gf180mcu_fd_sc_mcu7t5v0__aoi211_1
X_475_ _412_/Z _478_/B _495_/B VPWR VPWR VGND VGND gf180mcu_fd_sc_mcu7t5v0__nor2_2
Xwire4 wire4/I T[6] VPWR VPWR VGND VGND gf180mcu_fd_sc_mcu7t5v0__clkbuf_8
XFILLER_41_113 VPWR VPWR VGND VGND gf180mcu_fd_sc_mcu7t5v0__fill_1
XFILLER_26_198 VPWR VPWR VGND VGND gf180mcu_fd_sc_mcu7t5v0__fill_2
Xrebuffer73 _393_/B _430_/A2 VPWR VPWR VGND VGND gf180mcu_fd_sc_mcu7t5v0__buf_8
XTAP_TAPCELL_ROW_42_196 VPWR VGND gf180mcu_fd_sc_mcu7t5v0__filltie
X_458_ _461_/A1 _463_/A2 _457_/Z T[0] VPWR VPWR VGND VGND gf180mcu_fd_sc_mcu7t5v0__and3_2
X_389_ _339_/Z _377_/C _510_/A2 VPWR VPWR VGND VGND gf180mcu_fd_sc_mcu7t5v0__nor2_1
X_527_ _536_/A1 _527_/A2 _464_/B _526_/Z _529_/A3 VPWR VPWR VGND VGND gf180mcu_fd_sc_mcu7t5v0__oai22_1
XFILLER_2_37 VPWR VPWR VGND VGND gf180mcu_fd_sc_mcu7t5v0__fillcap_64
X_312_ _642_/Q _331_/C VPWR VPWR VGND VGND gf180mcu_fd_sc_mcu7t5v0__clkinv_1
XFILLER_11_116 VPWR VPWR VGND VGND gf180mcu_fd_sc_mcu7t5v0__fill_1
XFILLER_6_197 VPWR VPWR VGND VGND gf180mcu_fd_sc_mcu7t5v0__fill_2
XFILLER_10_193 VPWR VPWR VGND VGND gf180mcu_fd_sc_mcu7t5v0__fillcap_4
XFILLER_31_2 VPWR VPWR VGND VGND gf180mcu_fd_sc_mcu7t5v0__fillcap_4
XFILLER_0_70 VPWR VPWR VGND VGND gf180mcu_fd_sc_mcu7t5v0__fillcap_32
X_560_ _630_/Q _617_/B _630_/D VPWR VPWR VGND VGND gf180mcu_fd_sc_mcu7t5v0__xor2_1
X_491_ _491_/A1 _491_/A2 _491_/B _491_/C _498_/A2 VPWR VPWR VGND VGND gf180mcu_fd_sc_mcu7t5v0__aoi211_2
XFILLER_0_104 VPWR VPWR VGND VGND gf180mcu_fd_sc_mcu7t5v0__fillcap_32
XPHY_EDGE_ROW_22_Right_22 VPWR VGND gf180mcu_fd_sc_mcu7t5v0__endcap
XPHY_EDGE_ROW_13_Right_13 VPWR VGND gf180mcu_fd_sc_mcu7t5v0__endcap
XPHY_EDGE_ROW_40_Right_40 VPWR VGND gf180mcu_fd_sc_mcu7t5v0__endcap
XPHY_EDGE_ROW_31_Right_31 VPWR VGND gf180mcu_fd_sc_mcu7t5v0__endcap
XFILLER_30_34 VPWR VPWR VGND VGND gf180mcu_fd_sc_mcu7t5v0__fill_1
X_543_ _543_/A1 _543_/A2 _546_/B _543_/B2 _543_/C1 _369_/Z _545_/A3 VPWR VPWR VGND
+ VGND gf180mcu_fd_sc_mcu7t5v0__aoi222_1
X_612_ _643_/Q _614_/A3 _621_/A3 VPWR VPWR VGND VGND gf180mcu_fd_sc_mcu7t5v0__nand2_1
X_474_ _507_/A1 _471_/Z _512_/B _490_/A3 VPWR VPWR VGND VGND gf180mcu_fd_sc_mcu7t5v0__oai21_1
Xwire5 wire5/I T[5] VPWR VPWR VGND VGND gf180mcu_fd_sc_mcu7t5v0__buf_8
XFILLER_41_136 VPWR VPWR VGND VGND gf180mcu_fd_sc_mcu7t5v0__fillcap_4
Xrebuffer74 _341_/ZN _425_/A3 VPWR VPWR VGND VGND gf180mcu_fd_sc_mcu7t5v0__buf_8
X_526_ _551_/A1 _543_/C1 _526_/Z VPWR VPWR VGND VGND gf180mcu_fd_sc_mcu7t5v0__and2_1
XFILLER_9_2 VPWR VPWR VGND VGND gf180mcu_fd_sc_mcu7t5v0__fillcap_16
XTAP_TAPCELL_ROW_42_197 VPWR VGND gf180mcu_fd_sc_mcu7t5v0__filltie
X_457_ _457_/A1 _457_/A2 _457_/A3 T[4] _457_/Z VPWR VPWR VGND VGND gf180mcu_fd_sc_mcu7t5v0__or4_4
X_388_ _465_/B2 _535_/A1 _508_/A1 _487_/A1 _556_/A2 VPWR VPWR VGND VGND gf180mcu_fd_sc_mcu7t5v0__aoi22_2
X_311_ _347_/B _577_/A1 VPWR VPWR VGND VGND gf180mcu_fd_sc_mcu7t5v0__inv_2
X_509_ _509_/A1 _509_/A2 _509_/A3 _547_/A3 _522_/A1 VPWR VPWR VGND VGND gf180mcu_fd_sc_mcu7t5v0__nand4_1
XFILLER_22_46 VPWR VPWR VGND VGND gf180mcu_fd_sc_mcu7t5v0__fillcap_4
XFILLER_11_139 VPWR VPWR VGND VGND gf180mcu_fd_sc_mcu7t5v0__fill_1
XFILLER_10_161 VPWR VPWR VGND VGND gf180mcu_fd_sc_mcu7t5v0__fill_1
XFILLER_19_4 VPWR VPWR VGND VGND gf180mcu_fd_sc_mcu7t5v0__fill_1
XFILLER_24_2 VPWR VPWR VGND VGND gf180mcu_fd_sc_mcu7t5v0__fill_1
XFILLER_28_23 VPWR VPWR VGND VGND gf180mcu_fd_sc_mcu7t5v0__fill_2
XFILLER_0_138 VPWR VPWR VGND VGND gf180mcu_fd_sc_mcu7t5v0__fillcap_32
XFILLER_9_80 VPWR VPWR VGND VGND gf180mcu_fd_sc_mcu7t5v0__fillcap_4
XFILLER_9_91 VPWR VPWR VGND VGND gf180mcu_fd_sc_mcu7t5v0__fill_2
X_490_ _490_/A1 _530_/A4 _490_/A3 _490_/A4 _491_/C VPWR VPWR VGND VGND gf180mcu_fd_sc_mcu7t5v0__nand4_1
Xclkbuf_2_3__f_clk clkbuf_0_clk/Z _648_/CLK VPWR VPWR VGND VGND gf180mcu_fd_sc_mcu7t5v0__clkbuf_16
X_542_ _542_/A1 _542_/A2 _542_/A3 _542_/A4 _549_/A1 VPWR VPWR VGND VGND gf180mcu_fd_sc_mcu7t5v0__nand4_1
X_473_ _491_/A1 _502_/B _510_/B _551_/A1 _530_/A4 VPWR VPWR VGND VGND gf180mcu_fd_sc_mcu7t5v0__aoi22_1
X_611_ _643_/Q _625_/A1 _618_/B VPWR VPWR VGND VGND gf180mcu_fd_sc_mcu7t5v0__nand2_1
Xwire6 wire6/I T[2] VPWR VPWR VGND VGND gf180mcu_fd_sc_mcu7t5v0__clkbuf_4
Xrebuffer64 _345_/ZN _424_/A2 VPWR VPWR VGND VGND gf180mcu_fd_sc_mcu7t5v0__buf_8
Xrebuffer75 _393_/C _390_/A1 VPWR VPWR VGND VGND gf180mcu_fd_sc_mcu7t5v0__buf_8
X_456_ _457_/A3 _457_/A2 _457_/A1 T[4] _463_/A3 VPWR VPWR VGND VGND gf180mcu_fd_sc_mcu7t5v0__nor4_4
X_387_ _483_/A2 _387_/A2 _350_/Z _520_/A2 VPWR VPWR VGND VGND gf180mcu_fd_sc_mcu7t5v0__nor3_4
XTAP_TAPCELL_ROW_2_93 VPWR VGND gf180mcu_fd_sc_mcu7t5v0__filltie
X_525_ _512_/B _510_/B _525_/B1 _525_/B2 _529_/A2 VPWR VPWR VGND VGND gf180mcu_fd_sc_mcu7t5v0__oai22_1
X_310_ _641_/Q _327_/B VPWR VPWR VGND VGND gf180mcu_fd_sc_mcu7t5v0__clkinv_1
X_508_ _508_/A1 _508_/A2 _505_/B _508_/B2 _547_/A3 VPWR VPWR VGND VGND gf180mcu_fd_sc_mcu7t5v0__aoi22_1
XFILLER_20_107 VPWR VPWR VGND VGND gf180mcu_fd_sc_mcu7t5v0__fill_1
X_439_ _550_/B _541_/A3 _510_/B _545_/A1 VPWR VPWR VGND VGND gf180mcu_fd_sc_mcu7t5v0__oai21_1
XFILLER_9_174 VPWR VPWR VGND VGND gf180mcu_fd_sc_mcu7t5v0__fillcap_16
XFILLER_6_177 VPWR VPWR VGND VGND gf180mcu_fd_sc_mcu7t5v0__fillcap_16
XPHY_EDGE_ROW_5_Left_48 VPWR VGND gf180mcu_fd_sc_mcu7t5v0__endcap
XFILLER_6_199 VPWR VPWR VGND VGND gf180mcu_fd_sc_mcu7t5v0__fill_1
XFILLER_10_151 VPWR VPWR VGND VGND gf180mcu_fd_sc_mcu7t5v0__fillcap_8
XFILLER_33_68 VPWR VPWR VGND VGND gf180mcu_fd_sc_mcu7t5v0__fill_2
XFILLER_3_136 VPWR VPWR VGND VGND gf180mcu_fd_sc_mcu7t5v0__fillcap_4
XPHY_EDGE_ROW_8_Left_51 VPWR VGND gf180mcu_fd_sc_mcu7t5v0__endcap
XPHY_EDGE_ROW_7_Right_7 VPWR VGND gf180mcu_fd_sc_mcu7t5v0__endcap
XFILLER_39_67 VPWR VPWR VGND VGND gf180mcu_fd_sc_mcu7t5v0__fill_2
XPHY_EDGE_ROW_34_Left_77 VPWR VGND gf180mcu_fd_sc_mcu7t5v0__endcap
X_541_ _500_/B _540_/B _541_/A3 _541_/B _542_/A4 VPWR VPWR VGND VGND gf180mcu_fd_sc_mcu7t5v0__oai31_1
X_610_ _331_/C _617_/B _610_/B _642_/D VPWR VPWR VGND VGND gf180mcu_fd_sc_mcu7t5v0__oai21_1
X_472_ _551_/A2 _471_/Z _507_/B _490_/A1 VPWR VPWR VGND VGND gf180mcu_fd_sc_mcu7t5v0__oai21_1
Xwire7 wire7/I T[1] VPWR VPWR VGND VGND gf180mcu_fd_sc_mcu7t5v0__clkbuf_8
Xrebuffer76 _395_/A3 _483_/A2 VPWR VPWR VGND VGND gf180mcu_fd_sc_mcu7t5v0__buf_8
Xrebuffer65 _477_/A1 _391_/A1 VPWR VPWR VGND VGND gf180mcu_fd_sc_mcu7t5v0__buf_8
X_455_ _455_/A1 _555_/A1 T[4] VPWR VPWR VGND VGND gf180mcu_fd_sc_mcu7t5v0__nand2_4
X_386_ _441_/A1 _535_/A1 _386_/Z VPWR VPWR VGND VGND gf180mcu_fd_sc_mcu7t5v0__and2_1
XTAP_TAPCELL_ROW_2_94 VPWR VGND gf180mcu_fd_sc_mcu7t5v0__filltie
X_524_ _478_/C _524_/A2 _478_/B _525_/B1 VPWR VPWR VGND VGND gf180mcu_fd_sc_mcu7t5v0__nor3_1
XPHY_EDGE_ROW_37_Left_80 VPWR VGND gf180mcu_fd_sc_mcu7t5v0__endcap
X_438_ _516_/A1 _476_/B _438_/A3 _541_/A3 VPWR VPWR VGND VGND gf180mcu_fd_sc_mcu7t5v0__nand3_1
X_369_ _396_/A2 _445_/B _369_/Z VPWR VPWR VGND VGND gf180mcu_fd_sc_mcu7t5v0__and2_1
XPHY_EDGE_ROW_21_Left_64 VPWR VGND gf180mcu_fd_sc_mcu7t5v0__endcap
XFILLER_3_72 VPWR VPWR VGND VGND gf180mcu_fd_sc_mcu7t5v0__fillcap_64
XFILLER_9_142 VPWR VPWR VGND VGND gf180mcu_fd_sc_mcu7t5v0__fillcap_32
X_507_ _507_/A1 _397_/Z _507_/B _509_/A3 VPWR VPWR VGND VGND gf180mcu_fd_sc_mcu7t5v0__oai21_1
XFILLER_13_182 VPWR VPWR VGND VGND gf180mcu_fd_sc_mcu7t5v0__fillcap_16
XFILLER_6_101 VPWR VPWR VGND VGND gf180mcu_fd_sc_mcu7t5v0__fillcap_4
XFILLER_10_174 VPWR VPWR VGND VGND gf180mcu_fd_sc_mcu7t5v0__fill_1
XFILLER_12_70 VPWR VPWR VGND VGND gf180mcu_fd_sc_mcu7t5v0__fillcap_4
XFILLER_28_25 VPWR VPWR VGND VGND gf180mcu_fd_sc_mcu7t5v0__fill_1
XFILLER_9_60 VPWR VPWR VGND VGND gf180mcu_fd_sc_mcu7t5v0__fill_1
XFILLER_9_93 VPWR VPWR VGND VGND gf180mcu_fd_sc_mcu7t5v0__fill_1
XFILLER_38_199 VPWR VPWR VGND VGND gf180mcu_fd_sc_mcu7t5v0__fill_1
XFILLER_38_177 VPWR VPWR VGND VGND gf180mcu_fd_sc_mcu7t5v0__fill_1
X_540_ _448_/B _554_/B2 _540_/B _542_/A3 VPWR VPWR VGND VGND gf180mcu_fd_sc_mcu7t5v0__oai21_1
X_471_ _517_/A2 _395_/Z _471_/Z VPWR VPWR VGND VGND gf180mcu_fd_sc_mcu7t5v0__or2_1
Xrebuffer77 _434_/A4 _457_/A1 VPWR VPWR VGND VGND gf180mcu_fd_sc_mcu7t5v0__buf_8
Xrebuffer66 _387_/A2 _391_/A3 VPWR VPWR VGND VGND gf180mcu_fd_sc_mcu7t5v0__buf_8
X_454_ _502_/B _454_/A2 _510_/B _508_/B2 _489_/B _555_/A1 VPWR VPWR VGND VGND gf180mcu_fd_sc_mcu7t5v0__aoi221_4
XTAP_TAPCELL_ROW_2_95 VPWR VGND gf180mcu_fd_sc_mcu7t5v0__filltie
X_523_ _503_/Z _523_/A2 B[1] VPWR VPWR VGND VGND gf180mcu_fd_sc_mcu7t5v0__nand2_2
X_385_ _520_/A1 _385_/A2 _382_/Z _535_/A1 _519_/B _548_/A2 VPWR VPWR VGND VGND gf180mcu_fd_sc_mcu7t5v0__aoi221_4
XFILLER_7_2 VPWR VPWR VGND VGND gf180mcu_fd_sc_mcu7t5v0__fillcap_32
X_368_ _483_/A1 _393_/C _387_/A2 _406_/B VPWR VPWR VGND VGND gf180mcu_fd_sc_mcu7t5v0__nand3_2
XFILLER_9_198 VPWR VPWR VGND VGND gf180mcu_fd_sc_mcu7t5v0__fill_2
X_437_ _416_/Z _510_/B _455_/A1 VPWR VPWR VGND VGND gf180mcu_fd_sc_mcu7t5v0__nand2_1
XFILLER_13_150 VPWR VPWR VGND VGND gf180mcu_fd_sc_mcu7t5v0__fill_1
X_506_ _507_/A1 _397_/Z _506_/Z VPWR VPWR VGND VGND gf180mcu_fd_sc_mcu7t5v0__or2_1
XPHY_EDGE_ROW_29_Right_29 VPWR VGND gf180mcu_fd_sc_mcu7t5v0__endcap
XPHY_EDGE_ROW_38_Right_38 VPWR VGND gf180mcu_fd_sc_mcu7t5v0__endcap
XFILLER_10_197 VPWR VPWR VGND VGND gf180mcu_fd_sc_mcu7t5v0__fill_2
XFILLER_5_190 VPWR VPWR VGND VGND gf180mcu_fd_sc_mcu7t5v0__fillcap_8
XFILLER_2_193 VPWR VPWR VGND VGND gf180mcu_fd_sc_mcu7t5v0__fillcap_4
XFILLER_2_171 VPWR VPWR VGND VGND gf180mcu_fd_sc_mcu7t5v0__fillcap_4
XFILLER_9_72 VPWR VPWR VGND VGND gf180mcu_fd_sc_mcu7t5v0__fillcap_8
XFILLER_22_2 VPWR VPWR VGND VGND gf180mcu_fd_sc_mcu7t5v0__fill_1
XFILLER_39_69 VPWR VPWR VGND VGND gf180mcu_fd_sc_mcu7t5v0__fill_1
X_599_ _625_/A1 _599_/A2 _599_/B _641_/D VPWR VPWR VGND VGND gf180mcu_fd_sc_mcu7t5v0__oai21_1
X_470_ _542_/A1 _470_/A2 _491_/B VPWR VPWR VGND VGND gf180mcu_fd_sc_mcu7t5v0__nand2_1
Xrebuffer67 _381_/A2 _387_/A2 VPWR VPWR VGND VGND gf180mcu_fd_sc_mcu7t5v0__buf_8
Xrebuffer78 _348_/A1 _396_/A3 VPWR VPWR VGND VGND gf180mcu_fd_sc_mcu7t5v0__buf_8
X_522_ _522_/A1 _522_/A2 _522_/A3 _522_/A4 _523_/A2 VPWR VPWR VGND VGND gf180mcu_fd_sc_mcu7t5v0__nor4_2
X_384_ _453_/A1 _507_/A1 _420_/A1 _519_/B VPWR VPWR VGND VGND gf180mcu_fd_sc_mcu7t5v0__and3_2
X_453_ _453_/A1 _476_/A1 _333_/Z _520_/A2 _489_/B VPWR VPWR VGND VGND gf180mcu_fd_sc_mcu7t5v0__and4_1
XFILLER_22_173 VPWR VPWR VGND VGND gf180mcu_fd_sc_mcu7t5v0__fill_2
XTAP_TAPCELL_ROW_9_111 VPWR VGND gf180mcu_fd_sc_mcu7t5v0__filltie
X_505_ _355_/Z _527_/A2 _505_/B _509_/A2 VPWR VPWR VGND VGND gf180mcu_fd_sc_mcu7t5v0__oai21_1
X_367_ _339_/Z _396_/A3 _430_/A2 _551_/A2 VPWR VPWR VGND VGND gf180mcu_fd_sc_mcu7t5v0__nor3_4
X_436_ _478_/C _478_/B _436_/ZN VPWR VPWR VGND VGND gf180mcu_fd_sc_mcu7t5v0__nor2_1
XFILLER_9_133 VPWR VPWR VGND VGND gf180mcu_fd_sc_mcu7t5v0__fillcap_4
XTAP_TAPCELL_ROW_6_103 VPWR VGND gf180mcu_fd_sc_mcu7t5v0__filltie
XFILLER_12_94 VPWR VPWR VGND VGND gf180mcu_fd_sc_mcu7t5v0__fill_2
X_419_ _419_/A1 _419_/A2 _457_/A2 VPWR VPWR VGND VGND gf180mcu_fd_sc_mcu7t5v0__nand2_2
XFILLER_33_16 VPWR VPWR VGND VGND gf180mcu_fd_sc_mcu7t5v0__fill_1
XFILLER_9_84 VPWR VPWR VGND VGND gf180mcu_fd_sc_mcu7t5v0__fill_1
XFILLER_15_2 VPWR VPWR VGND VGND gf180mcu_fd_sc_mcu7t5v0__fill_2
Xrebuffer79 _348_/A1 _430_/A1 VPWR VPWR VGND VGND gf180mcu_fd_sc_mcu7t5v0__buf_8
X_598_ _641_/Q _625_/A1 _599_/B VPWR VPWR VGND VGND gf180mcu_fd_sc_mcu7t5v0__nand2_1
XFILLER_6_85 VPWR VPWR VGND VGND gf180mcu_fd_sc_mcu7t5v0__fillcap_16
Xrebuffer68 _414_/A1 _377_/B2 VPWR VPWR VGND VGND gf180mcu_fd_sc_mcu7t5v0__buf_8
X_452_ _547_/A1 _452_/A2 _493_/A1 _452_/A4 _457_/A3 VPWR VPWR VGND VGND gf180mcu_fd_sc_mcu7t5v0__nand4_2
X_521_ _521_/A1 _521_/A2 _521_/A3 _521_/A4 _522_/A4 VPWR VPWR VGND VGND gf180mcu_fd_sc_mcu7t5v0__nand4_1
X_383_ _535_/A1 _382_/Z _533_/A1 VPWR VPWR VGND VGND gf180mcu_fd_sc_mcu7t5v0__nand2_1
XTAP_TAPCELL_ROW_18_133 VPWR VGND gf180mcu_fd_sc_mcu7t5v0__filltie
XFILLER_16_193 VPWR VPWR VGND VGND gf180mcu_fd_sc_mcu7t5v0__fillcap_4
XTAP_TAPCELL_ROW_41_191 VPWR VGND gf180mcu_fd_sc_mcu7t5v0__filltie
X_366_ _516_/A1 _428_/A2 _528_/B2 VPWR VPWR VGND VGND gf180mcu_fd_sc_mcu7t5v0__nand2_1
X_504_ _551_/A1 _504_/A2 _512_/B _509_/A1 VPWR VPWR VGND VGND gf180mcu_fd_sc_mcu7t5v0__oai21_1
X_435_ _435_/A1 _435_/A2 _435_/A3 _435_/A4 _478_/B VPWR VPWR VGND VGND gf180mcu_fd_sc_mcu7t5v0__nand4_2
XTAP_TAPCELL_ROW_9_112 VPWR VGND gf180mcu_fd_sc_mcu7t5v0__filltie
XTAP_TAPCELL_ROW_6_104 VPWR VGND gf180mcu_fd_sc_mcu7t5v0__filltie
XFILLER_10_177 VPWR VPWR VGND VGND gf180mcu_fd_sc_mcu7t5v0__fillcap_16
XFILLER_10_199 VPWR VPWR VGND VGND gf180mcu_fd_sc_mcu7t5v0__fill_1
X_349_ _483_/A1 _483_/A2 _393_/B _415_/A1 VPWR VPWR VGND VGND gf180mcu_fd_sc_mcu7t5v0__nand3_4
XPHY_EDGE_ROW_25_Left_68 VPWR VGND gf180mcu_fd_sc_mcu7t5v0__endcap
X_418_ _465_/A2 _550_/B _419_/A1 VPWR VPWR VGND VGND gf180mcu_fd_sc_mcu7t5v0__nand2_1
XFILLER_23_72 VPWR VPWR VGND VGND gf180mcu_fd_sc_mcu7t5v0__fillcap_4
XPHY_EDGE_ROW_28_Left_71 VPWR VGND gf180mcu_fd_sc_mcu7t5v0__endcap
XPHY_EDGE_ROW_12_Left_55 VPWR VGND gf180mcu_fd_sc_mcu7t5v0__endcap
XTAP_TAPCELL_ROW_39_186 VPWR VGND gf180mcu_fd_sc_mcu7t5v0__filltie
X_597_ _595_/Z _597_/A2 _599_/A2 VPWR VPWR VGND VGND gf180mcu_fd_sc_mcu7t5v0__nand2_1
XTAP_TAPCELL_ROW_36_178 VPWR VGND gf180mcu_fd_sc_mcu7t5v0__filltie
Xrebuffer69 _449_/A1 _414_/A1 VPWR VPWR VGND VGND gf180mcu_fd_sc_mcu7t5v0__buf_8
X_520_ _520_/A1 _520_/A2 _510_/B _520_/B2 _521_/A4 VPWR VPWR VGND VGND gf180mcu_fd_sc_mcu7t5v0__aoi22_1
X_451_ _543_/A2 _451_/A2 _451_/B1 _432_/B _508_/A2 _540_/B _452_/A2 VPWR VPWR VGND
+ VGND gf180mcu_fd_sc_mcu7t5v0__aoi222_2
XTAP_TAPCELL_ROW_27_156 VPWR VGND gf180mcu_fd_sc_mcu7t5v0__filltie
XTAP_TAPCELL_ROW_18_134 VPWR VGND gf180mcu_fd_sc_mcu7t5v0__filltie
X_382_ _525_/B2 _536_/A4 _382_/Z VPWR VPWR VGND VGND gf180mcu_fd_sc_mcu7t5v0__or2_4
XTAP_TAPCELL_ROW_41_192 VPWR VGND gf180mcu_fd_sc_mcu7t5v0__filltie
XTAP_TAPCELL_ROW_24_148 VPWR VGND gf180mcu_fd_sc_mcu7t5v0__filltie
X_434_ _434_/A1 _411_/Z _457_/A2 _434_/A4 _459_/A1 VPWR VPWR VGND VGND gf180mcu_fd_sc_mcu7t5v0__nor4_4
X_365_ _582_/A1 _577_/A1 _393_/C _424_/A2 _428_/A2 VPWR VPWR VGND VGND gf180mcu_fd_sc_mcu7t5v0__nand4_2
XTAP_TAPCELL_ROW_32_170 VPWR VGND gf180mcu_fd_sc_mcu7t5v0__filltie
X_503_ _503_/A1 _499_/Z _503_/A3 _503_/A4 _503_/Z VPWR VPWR VGND VGND gf180mcu_fd_sc_mcu7t5v0__and4_1
XTAP_TAPCELL_ROW_15_126 VPWR VGND gf180mcu_fd_sc_mcu7t5v0__filltie
XTAP_TAPCELL_ROW_20_140 VPWR VGND gf180mcu_fd_sc_mcu7t5v0__filltie
XTAP_TAPCELL_ROW_6_105 VPWR VGND gf180mcu_fd_sc_mcu7t5v0__filltie
XTAP_TAPCELL_ROW_12_118 VPWR VGND gf180mcu_fd_sc_mcu7t5v0__filltie
X_348_ _348_/A1 _393_/B _393_/A1 _543_/A1 VPWR VPWR VGND VGND gf180mcu_fd_sc_mcu7t5v0__nor3_4
XPHY_EDGE_ROW_25_Right_25 VPWR VGND gf180mcu_fd_sc_mcu7t5v0__endcap
XPHY_EDGE_ROW_16_Right_16 VPWR VGND gf180mcu_fd_sc_mcu7t5v0__endcap
X_417_ _465_/A2 _416_/Z _419_/A2 VPWR VPWR VGND VGND gf180mcu_fd_sc_mcu7t5v0__nand2_1
XFILLER_5_2 VPWR VPWR VGND VGND gf180mcu_fd_sc_mcu7t5v0__fillcap_64
XPHY_EDGE_ROW_0_Left_43 VPWR VGND gf180mcu_fd_sc_mcu7t5v0__endcap
XPHY_EDGE_ROW_42_Left_85 VPWR VGND gf180mcu_fd_sc_mcu7t5v0__endcap
XPHY_EDGE_ROW_34_Right_34 VPWR VGND gf180mcu_fd_sc_mcu7t5v0__endcap
XTAP_TAPCELL_ROW_39_187 VPWR VGND gf180mcu_fd_sc_mcu7t5v0__filltie
XPHY_EDGE_ROW_2_Right_2 VPWR VGND gf180mcu_fd_sc_mcu7t5v0__endcap
X_596_ _596_/A1 _593_/Z _597_/A2 VPWR VPWR VGND VGND gf180mcu_fd_sc_mcu7t5v0__nand2_1
XTAP_TAPCELL_ROW_36_179 VPWR VGND gf180mcu_fd_sc_mcu7t5v0__filltie
XFILLER_26_107 VPWR VPWR VGND VGND gf180mcu_fd_sc_mcu7t5v0__fill_2
XFILLER_20_2 VPWR VPWR VGND VGND gf180mcu_fd_sc_mcu7t5v0__fill_1
XFILLER_40_198 VPWR VPWR VGND VGND gf180mcu_fd_sc_mcu7t5v0__fill_2
X_381_ _393_/C _381_/A2 _406_/A2 _546_/A1 VPWR VPWR VGND VGND gf180mcu_fd_sc_mcu7t5v0__nor3_4
XTAP_TAPCELL_ROW_27_157 VPWR VGND gf180mcu_fd_sc_mcu7t5v0__filltie
X_450_ _448_/B _546_/A2 _508_/A2 _450_/B2 _493_/A1 VPWR VPWR VGND VGND gf180mcu_fd_sc_mcu7t5v0__aoi22_1
X_648_ _648_/D _648_/CLK _648_/Q VPWR VPWR VGND VGND gf180mcu_fd_sc_mcu7t5v0__dffq_1
X_579_ _579_/A1 _579_/A2 _579_/B _589_/A1 VPWR VPWR VGND VGND gf180mcu_fd_sc_mcu7t5v0__oai21_2
XTAP_TAPCELL_ROW_18_135 VPWR VGND gf180mcu_fd_sc_mcu7t5v0__filltie
X_433_ _503_/A1 _433_/A2 _552_/A4 _433_/A4 _434_/A1 VPWR VPWR VGND VGND gf180mcu_fd_sc_mcu7t5v0__nand4_1
XTAP_TAPCELL_ROW_24_149 VPWR VGND gf180mcu_fd_sc_mcu7t5v0__filltie
XFILLER_22_198 VPWR VPWR VGND VGND gf180mcu_fd_sc_mcu7t5v0__fill_2
X_502_ _382_/Z _501_/Z _502_/B _503_/A4 VPWR VPWR VGND VGND gf180mcu_fd_sc_mcu7t5v0__oai21_1
XFILLER_3_66 VPWR VPWR VGND VGND gf180mcu_fd_sc_mcu7t5v0__fillcap_4
XFILLER_13_198 VPWR VPWR VGND VGND gf180mcu_fd_sc_mcu7t5v0__fill_2
X_364_ _364_/A1 _430_/A3 _504_/A2 VPWR VPWR VGND VGND gf180mcu_fd_sc_mcu7t5v0__nor2_1
XTAP_TAPCELL_ROW_15_127 VPWR VGND gf180mcu_fd_sc_mcu7t5v0__filltie
XTAP_TAPCELL_ROW_12_119 VPWR VGND gf180mcu_fd_sc_mcu7t5v0__filltie
X_347_ _338_/B _337_/Z _347_/B _406_/A2 VPWR VPWR VGND VGND gf180mcu_fd_sc_mcu7t5v0__oai21_4
X_416_ _536_/A4 _540_/B _527_/A2 _395_/Z _416_/Z VPWR VPWR VGND VGND gf180mcu_fd_sc_mcu7t5v0__or4_2
XFILLER_2_197 VPWR VPWR VGND VGND gf180mcu_fd_sc_mcu7t5v0__fill_2
XFILLER_38_138 VPWR VPWR VGND VGND gf180mcu_fd_sc_mcu7t5v0__fill_2
Xload_slew40 _520_/A2 _508_/A1 VPWR VPWR VGND VGND gf180mcu_fd_sc_mcu7t5v0__buf_2
Xload_slew51 _441_/A1 _465_/B2 VPWR VPWR VGND VGND gf180mcu_fd_sc_mcu7t5v0__clkbuf_2
XFILLER_29_51 VPWR VPWR VGND VGND gf180mcu_fd_sc_mcu7t5v0__fill_2
X_595_ _596_/A1 _593_/Z _595_/Z VPWR VPWR VGND VGND gf180mcu_fd_sc_mcu7t5v0__or2_1
XFILLER_20_20 VPWR VPWR VGND VGND gf180mcu_fd_sc_mcu7t5v0__fill_2
XFILLER_34_174 VPWR VPWR VGND VGND gf180mcu_fd_sc_mcu7t5v0__fill_1
XFILLER_6_77 VPWR VPWR VGND VGND gf180mcu_fd_sc_mcu7t5v0__fill_2
XFILLER_40_144 VPWR VPWR VGND VGND gf180mcu_fd_sc_mcu7t5v0__fill_2
X_380_ _453_/A1 _420_/A1 _380_/Z VPWR VPWR VGND VGND gf180mcu_fd_sc_mcu7t5v0__and2_2
X_647_ _647_/D _647_/CLK _647_/Q VPWR VPWR VGND VGND gf180mcu_fd_sc_mcu7t5v0__dffq_1
X_578_ _347_/B _636_/Q _579_/B VPWR VPWR VGND VGND gf180mcu_fd_sc_mcu7t5v0__nor2_1
.ends
