* NGSPICE file created from tt_um_transmit_5_3.ext - technology: gf180mcuD

* Black-box entry subcircuit for gf180mcu_fd_sc_mcu7t5v0__fillcap_4 abstract view
.subckt gf180mcu_fd_sc_mcu7t5v0__fillcap_4 VDD VNW VPW VSS
.ends

* Black-box entry subcircuit for gf180mcu_fd_sc_mcu7t5v0__or2_1 abstract view
.subckt gf180mcu_fd_sc_mcu7t5v0__or2_1 A1 A2 Z VDD VNW VPW VSS
.ends

* Black-box entry subcircuit for gf180mcu_fd_sc_mcu7t5v0__clkbuf_1 abstract view
.subckt gf180mcu_fd_sc_mcu7t5v0__clkbuf_1 I Z VDD VNW VPW VSS
.ends

* Black-box entry subcircuit for gf180mcu_fd_sc_mcu7t5v0__endcap abstract view
.subckt gf180mcu_fd_sc_mcu7t5v0__endcap VDD VSS
.ends

* Black-box entry subcircuit for gf180mcu_fd_sc_mcu7t5v0__oai31_1 abstract view
.subckt gf180mcu_fd_sc_mcu7t5v0__oai31_1 A1 A2 A3 B ZN VDD VNW VPW VSS
.ends

* Black-box entry subcircuit for gf180mcu_fd_sc_mcu7t5v0__nor2_4 abstract view
.subckt gf180mcu_fd_sc_mcu7t5v0__nor2_4 A1 A2 ZN VDD VNW VPW VSS
.ends

* Black-box entry subcircuit for gf180mcu_fd_sc_mcu7t5v0__filltie abstract view
.subckt gf180mcu_fd_sc_mcu7t5v0__filltie VDD VSS
.ends

* Black-box entry subcircuit for gf180mcu_fd_sc_mcu7t5v0__fill_1 abstract view
.subckt gf180mcu_fd_sc_mcu7t5v0__fill_1 VDD VNW VPW VSS
.ends

* Black-box entry subcircuit for gf180mcu_fd_sc_mcu7t5v0__nor3_4 abstract view
.subckt gf180mcu_fd_sc_mcu7t5v0__nor3_4 A1 A2 A3 ZN VDD VNW VPW VSS
.ends

* Black-box entry subcircuit for gf180mcu_fd_sc_mcu7t5v0__fillcap_64 abstract view
.subckt gf180mcu_fd_sc_mcu7t5v0__fillcap_64 VDD VNW VPW VSS
.ends

* Black-box entry subcircuit for gf180mcu_fd_sc_mcu7t5v0__fill_2 abstract view
.subckt gf180mcu_fd_sc_mcu7t5v0__fill_2 VDD VNW VPW VSS
.ends

* Black-box entry subcircuit for gf180mcu_fd_sc_mcu7t5v0__oai21_4 abstract view
.subckt gf180mcu_fd_sc_mcu7t5v0__oai21_4 A1 A2 B ZN VDD VNW VPW VSS
.ends

* Black-box entry subcircuit for gf180mcu_fd_sc_mcu7t5v0__xor2_1 abstract view
.subckt gf180mcu_fd_sc_mcu7t5v0__xor2_1 A1 A2 Z VDD VNW VPW VSS
.ends

* Black-box entry subcircuit for gf180mcu_fd_sc_mcu7t5v0__buf_4 abstract view
.subckt gf180mcu_fd_sc_mcu7t5v0__buf_4 I Z VDD VNW VPW VSS
.ends

* Black-box entry subcircuit for gf180mcu_fd_sc_mcu7t5v0__xnor2_1 abstract view
.subckt gf180mcu_fd_sc_mcu7t5v0__xnor2_1 A1 A2 ZN VDD VNW VPW VSS
.ends

* Black-box entry subcircuit for gf180mcu_fd_sc_mcu7t5v0__aoi22_4 abstract view
.subckt gf180mcu_fd_sc_mcu7t5v0__aoi22_4 A1 A2 B1 B2 ZN VDD VNW VPW VSS
.ends

* Black-box entry subcircuit for gf180mcu_fd_sc_mcu7t5v0__oai21_1 abstract view
.subckt gf180mcu_fd_sc_mcu7t5v0__oai21_1 A1 A2 B ZN VDD VNW VPW VSS
.ends

* Black-box entry subcircuit for gf180mcu_fd_sc_mcu7t5v0__nand2_2 abstract view
.subckt gf180mcu_fd_sc_mcu7t5v0__nand2_2 A1 A2 ZN VDD VNW VPW VSS
.ends

* Black-box entry subcircuit for gf180mcu_fd_sc_mcu7t5v0__oai32_4 abstract view
.subckt gf180mcu_fd_sc_mcu7t5v0__oai32_4 A1 A2 A3 B1 B2 ZN VDD VNW VPW VSS
.ends

* Black-box entry subcircuit for gf180mcu_fd_sc_mcu7t5v0__fillcap_8 abstract view
.subckt gf180mcu_fd_sc_mcu7t5v0__fillcap_8 VDD VNW VPW VSS
.ends

* Black-box entry subcircuit for gf180mcu_fd_sc_mcu7t5v0__fillcap_32 abstract view
.subckt gf180mcu_fd_sc_mcu7t5v0__fillcap_32 VDD VNW VPW VSS
.ends

* Black-box entry subcircuit for gf180mcu_fd_sc_mcu7t5v0__fillcap_16 abstract view
.subckt gf180mcu_fd_sc_mcu7t5v0__fillcap_16 VDD VNW VPW VSS
.ends

* Black-box entry subcircuit for gf180mcu_fd_sc_mcu7t5v0__buf_2 abstract view
.subckt gf180mcu_fd_sc_mcu7t5v0__buf_2 I Z VDD VNW VPW VSS
.ends

* Black-box entry subcircuit for gf180mcu_fd_sc_mcu7t5v0__aoi21_1 abstract view
.subckt gf180mcu_fd_sc_mcu7t5v0__aoi21_1 A1 A2 B ZN VDD VNW VPW VSS
.ends

* Black-box entry subcircuit for gf180mcu_fd_sc_mcu7t5v0__clkinv_8 abstract view
.subckt gf180mcu_fd_sc_mcu7t5v0__clkinv_8 I ZN VDD VNW VPW VSS
.ends

* Black-box entry subcircuit for gf180mcu_fd_sc_mcu7t5v0__nor2_2 abstract view
.subckt gf180mcu_fd_sc_mcu7t5v0__nor2_2 A1 A2 ZN VDD VNW VPW VSS
.ends

* Black-box entry subcircuit for gf180mcu_fd_sc_mcu7t5v0__nor2_1 abstract view
.subckt gf180mcu_fd_sc_mcu7t5v0__nor2_1 A1 A2 ZN VDD VNW VPW VSS
.ends

* Black-box entry subcircuit for gf180mcu_fd_sc_mcu7t5v0__aoi22_1 abstract view
.subckt gf180mcu_fd_sc_mcu7t5v0__aoi22_1 A1 A2 B1 B2 ZN VDD VNW VPW VSS
.ends

* Black-box entry subcircuit for gf180mcu_fd_sc_mcu7t5v0__or3_2 abstract view
.subckt gf180mcu_fd_sc_mcu7t5v0__or3_2 A1 A2 A3 Z VDD VNW VPW VSS
.ends

* Black-box entry subcircuit for gf180mcu_fd_sc_mcu7t5v0__aoi21_2 abstract view
.subckt gf180mcu_fd_sc_mcu7t5v0__aoi21_2 A1 A2 B ZN VDD VNW VPW VSS
.ends

* Black-box entry subcircuit for gf180mcu_fd_sc_mcu7t5v0__nand3_4 abstract view
.subckt gf180mcu_fd_sc_mcu7t5v0__nand3_4 A1 A2 A3 ZN VDD VNW VPW VSS
.ends

* Black-box entry subcircuit for gf180mcu_fd_sc_mcu7t5v0__nand2_1 abstract view
.subckt gf180mcu_fd_sc_mcu7t5v0__nand2_1 A1 A2 ZN VDD VNW VPW VSS
.ends

* Black-box entry subcircuit for gf180mcu_fd_sc_mcu7t5v0__nor3_2 abstract view
.subckt gf180mcu_fd_sc_mcu7t5v0__nor3_2 A1 A2 A3 ZN VDD VNW VPW VSS
.ends

* Black-box entry subcircuit for gf180mcu_fd_sc_mcu7t5v0__buf_1 abstract view
.subckt gf180mcu_fd_sc_mcu7t5v0__buf_1 I Z VDD VNW VPW VSS
.ends

* Black-box entry subcircuit for gf180mcu_fd_sc_mcu7t5v0__nor4_4 abstract view
.subckt gf180mcu_fd_sc_mcu7t5v0__nor4_4 A1 A2 A3 A4 ZN VDD VNW VPW VSS
.ends

* Black-box entry subcircuit for gf180mcu_fd_sc_mcu7t5v0__dffrnq_1 abstract view
.subckt gf180mcu_fd_sc_mcu7t5v0__dffrnq_1 D RN CLK Q VDD VNW VPW VSS
.ends

* Black-box entry subcircuit for gf180mcu_fd_sc_mcu7t5v0__nand3_1 abstract view
.subckt gf180mcu_fd_sc_mcu7t5v0__nand3_1 A1 A2 A3 ZN VDD VNW VPW VSS
.ends

* Black-box entry subcircuit for gf180mcu_fd_sc_mcu7t5v0__or2_2 abstract view
.subckt gf180mcu_fd_sc_mcu7t5v0__or2_2 A1 A2 Z VDD VNW VPW VSS
.ends

* Black-box entry subcircuit for gf180mcu_fd_sc_mcu7t5v0__clkbuf_2 abstract view
.subckt gf180mcu_fd_sc_mcu7t5v0__clkbuf_2 I Z VDD VNW VPW VSS
.ends

* Black-box entry subcircuit for gf180mcu_fd_sc_mcu7t5v0__oai211_1 abstract view
.subckt gf180mcu_fd_sc_mcu7t5v0__oai211_1 A1 A2 B C ZN VDD VNW VPW VSS
.ends

* Black-box entry subcircuit for gf180mcu_fd_sc_mcu7t5v0__dffrnq_2 abstract view
.subckt gf180mcu_fd_sc_mcu7t5v0__dffrnq_2 D RN CLK Q VDD VNW VPW VSS
.ends

* Black-box entry subcircuit for gf180mcu_fd_sc_mcu7t5v0__nor3_1 abstract view
.subckt gf180mcu_fd_sc_mcu7t5v0__nor3_1 A1 A2 A3 ZN VDD VNW VPW VSS
.ends

* Black-box entry subcircuit for gf180mcu_fd_sc_mcu7t5v0__nand4_2 abstract view
.subckt gf180mcu_fd_sc_mcu7t5v0__nand4_2 A1 A2 A3 A4 ZN VDD VNW VPW VSS
.ends

* Black-box entry subcircuit for gf180mcu_fd_sc_mcu7t5v0__oai221_4 abstract view
.subckt gf180mcu_fd_sc_mcu7t5v0__oai221_4 A1 A2 B1 B2 C ZN VDD VNW VPW VSS
.ends

* Black-box entry subcircuit for gf180mcu_fd_sc_mcu7t5v0__clkinv_1 abstract view
.subckt gf180mcu_fd_sc_mcu7t5v0__clkinv_1 I ZN VDD VNW VPW VSS
.ends

* Black-box entry subcircuit for gf180mcu_fd_sc_mcu7t5v0__oai221_1 abstract view
.subckt gf180mcu_fd_sc_mcu7t5v0__oai221_1 A1 A2 B1 B2 C ZN VDD VNW VPW VSS
.ends

* Black-box entry subcircuit for gf180mcu_fd_sc_mcu7t5v0__xor3_1 abstract view
.subckt gf180mcu_fd_sc_mcu7t5v0__xor3_1 A1 A2 A3 Z VDD VNW VPW VSS
.ends

* Black-box entry subcircuit for gf180mcu_fd_sc_mcu7t5v0__inv_2 abstract view
.subckt gf180mcu_fd_sc_mcu7t5v0__inv_2 I ZN VDD VNW VPW VSS
.ends

* Black-box entry subcircuit for gf180mcu_fd_sc_mcu7t5v0__clkbuf_16 abstract view
.subckt gf180mcu_fd_sc_mcu7t5v0__clkbuf_16 I Z VDD VNW VPW VSS
.ends

* Black-box entry subcircuit for gf180mcu_fd_sc_mcu7t5v0__nand4_4 abstract view
.subckt gf180mcu_fd_sc_mcu7t5v0__nand4_4 A1 A2 A3 A4 ZN VDD VNW VPW VSS
.ends

* Black-box entry subcircuit for gf180mcu_fd_sc_mcu7t5v0__nand4_1 abstract view
.subckt gf180mcu_fd_sc_mcu7t5v0__nand4_1 A1 A2 A3 A4 ZN VDD VNW VPW VSS
.ends

* Black-box entry subcircuit for gf180mcu_fd_sc_mcu7t5v0__dlyb_1 abstract view
.subckt gf180mcu_fd_sc_mcu7t5v0__dlyb_1 I Z VDD VNW VPW VSS
.ends

* Black-box entry subcircuit for gf180mcu_fd_sc_mcu7t5v0__or4_2 abstract view
.subckt gf180mcu_fd_sc_mcu7t5v0__or4_2 A1 A2 A3 A4 Z VDD VNW VPW VSS
.ends

* Black-box entry subcircuit for gf180mcu_fd_sc_mcu7t5v0__aoi211_2 abstract view
.subckt gf180mcu_fd_sc_mcu7t5v0__aoi211_2 A1 A2 B C ZN VDD VNW VPW VSS
.ends

* Black-box entry subcircuit for gf180mcu_fd_sc_mcu7t5v0__and4_1 abstract view
.subckt gf180mcu_fd_sc_mcu7t5v0__and4_1 A1 A2 A3 A4 Z VDD VNW VPW VSS
.ends

* Black-box entry subcircuit for gf180mcu_fd_sc_mcu7t5v0__dffrnq_4 abstract view
.subckt gf180mcu_fd_sc_mcu7t5v0__dffrnq_4 D RN CLK Q VDD VNW VPW VSS
.ends

* Black-box entry subcircuit for gf180mcu_fd_sc_mcu7t5v0__aoi211_1 abstract view
.subckt gf180mcu_fd_sc_mcu7t5v0__aoi211_1 A1 A2 B C ZN VDD VNW VPW VSS
.ends

* Black-box entry subcircuit for gf180mcu_fd_sc_mcu7t5v0__inv_1 abstract view
.subckt gf180mcu_fd_sc_mcu7t5v0__inv_1 I ZN VDD VNW VPW VSS
.ends

* Black-box entry subcircuit for gf180mcu_fd_sc_mcu7t5v0__and2_1 abstract view
.subckt gf180mcu_fd_sc_mcu7t5v0__and2_1 A1 A2 Z VDD VNW VPW VSS
.ends

* Black-box entry subcircuit for gf180mcu_fd_sc_mcu7t5v0__or4_4 abstract view
.subckt gf180mcu_fd_sc_mcu7t5v0__or4_4 A1 A2 A3 A4 Z VDD VNW VPW VSS
.ends

* Black-box entry subcircuit for gf180mcu_fd_sc_mcu7t5v0__and3_1 abstract view
.subckt gf180mcu_fd_sc_mcu7t5v0__and3_1 A1 A2 A3 Z VDD VNW VPW VSS
.ends

* Black-box entry subcircuit for gf180mcu_fd_sc_mcu7t5v0__buf_3 abstract view
.subckt gf180mcu_fd_sc_mcu7t5v0__buf_3 I Z VDD VNW VPW VSS
.ends

* Black-box entry subcircuit for gf180mcu_fd_sc_mcu7t5v0__xor2_2 abstract view
.subckt gf180mcu_fd_sc_mcu7t5v0__xor2_2 A1 A2 Z VDD VNW VPW VSS
.ends

* Black-box entry subcircuit for gf180mcu_fd_sc_mcu7t5v0__oai31_2 abstract view
.subckt gf180mcu_fd_sc_mcu7t5v0__oai31_2 A1 A2 A3 B ZN VDD VNW VPW VSS
.ends

* Black-box entry subcircuit for gf180mcu_fd_sc_mcu7t5v0__oai22_2 abstract view
.subckt gf180mcu_fd_sc_mcu7t5v0__oai22_2 A1 A2 B1 B2 ZN VDD VNW VPW VSS
.ends

* Black-box entry subcircuit for gf180mcu_fd_sc_mcu7t5v0__and4_2 abstract view
.subckt gf180mcu_fd_sc_mcu7t5v0__and4_2 A1 A2 A3 A4 Z VDD VNW VPW VSS
.ends

* Black-box entry subcircuit for gf180mcu_fd_sc_mcu7t5v0__oai31_4 abstract view
.subckt gf180mcu_fd_sc_mcu7t5v0__oai31_4 A1 A2 A3 B ZN VDD VNW VPW VSS
.ends

* Black-box entry subcircuit for gf180mcu_fd_sc_mcu7t5v0__or2_4 abstract view
.subckt gf180mcu_fd_sc_mcu7t5v0__or2_4 A1 A2 Z VDD VNW VPW VSS
.ends

* Black-box entry subcircuit for gf180mcu_fd_sc_mcu7t5v0__and3_2 abstract view
.subckt gf180mcu_fd_sc_mcu7t5v0__and3_2 A1 A2 A3 Z VDD VNW VPW VSS
.ends

* Black-box entry subcircuit for gf180mcu_fd_sc_mcu7t5v0__or3_1 abstract view
.subckt gf180mcu_fd_sc_mcu7t5v0__or3_1 A1 A2 A3 Z VDD VNW VPW VSS
.ends

* Black-box entry subcircuit for gf180mcu_fd_sc_mcu7t5v0__aoi21_4 abstract view
.subckt gf180mcu_fd_sc_mcu7t5v0__aoi21_4 A1 A2 B ZN VDD VNW VPW VSS
.ends

* Black-box entry subcircuit for gf180mcu_fd_sc_mcu7t5v0__nand3_2 abstract view
.subckt gf180mcu_fd_sc_mcu7t5v0__nand3_2 A1 A2 A3 ZN VDD VNW VPW VSS
.ends

* Black-box entry subcircuit for gf180mcu_fd_sc_mcu7t5v0__oai21_2 abstract view
.subckt gf180mcu_fd_sc_mcu7t5v0__oai21_2 A1 A2 B ZN VDD VNW VPW VSS
.ends

* Black-box entry subcircuit for gf180mcu_fd_sc_mcu7t5v0__nand2_4 abstract view
.subckt gf180mcu_fd_sc_mcu7t5v0__nand2_4 A1 A2 ZN VDD VNW VPW VSS
.ends

* Black-box entry subcircuit for gf180mcu_fd_sc_mcu7t5v0__aoi221_4 abstract view
.subckt gf180mcu_fd_sc_mcu7t5v0__aoi221_4 A1 A2 B1 B2 C ZN VDD VNW VPW VSS
.ends

* Black-box entry subcircuit for gf180mcu_fd_sc_mcu7t5v0__oai211_4 abstract view
.subckt gf180mcu_fd_sc_mcu7t5v0__oai211_4 A1 A2 B C ZN VDD VNW VPW VSS
.ends

* Black-box entry subcircuit for gf180mcu_fd_sc_mcu7t5v0__mux2_2 abstract view
.subckt gf180mcu_fd_sc_mcu7t5v0__mux2_2 I0 I1 S Z VDD VNW VPW VSS
.ends

* Black-box entry subcircuit for gf180mcu_fd_sc_mcu7t5v0__xor2_4 abstract view
.subckt gf180mcu_fd_sc_mcu7t5v0__xor2_4 A1 A2 Z VDD VNW VPW VSS
.ends

* Black-box entry subcircuit for gf180mcu_fd_sc_mcu7t5v0__aoi211_4 abstract view
.subckt gf180mcu_fd_sc_mcu7t5v0__aoi211_4 A1 A2 B C ZN VDD VNW VPW VSS
.ends

* Black-box entry subcircuit for gf180mcu_fd_sc_mcu7t5v0__xnor2_2 abstract view
.subckt gf180mcu_fd_sc_mcu7t5v0__xnor2_2 A1 A2 ZN VDD VNW VPW VSS
.ends

* Black-box entry subcircuit for gf180mcu_fd_sc_mcu7t5v0__clkbuf_8 abstract view
.subckt gf180mcu_fd_sc_mcu7t5v0__clkbuf_8 I Z VDD VNW VPW VSS
.ends

* Black-box entry subcircuit for gf180mcu_fd_sc_mcu7t5v0__or4_1 abstract view
.subckt gf180mcu_fd_sc_mcu7t5v0__or4_1 A1 A2 A3 A4 Z VDD VNW VPW VSS
.ends

* Black-box entry subcircuit for gf180mcu_fd_sc_mcu7t5v0__buf_8 abstract view
.subckt gf180mcu_fd_sc_mcu7t5v0__buf_8 I Z VDD VNW VPW VSS
.ends

* Black-box entry subcircuit for gf180mcu_fd_sc_mcu7t5v0__and3_4 abstract view
.subckt gf180mcu_fd_sc_mcu7t5v0__and3_4 A1 A2 A3 Z VDD VNW VPW VSS
.ends

* Black-box entry subcircuit for gf180mcu_fd_sc_mcu7t5v0__aoi222_2 abstract view
.subckt gf180mcu_fd_sc_mcu7t5v0__aoi222_2 A1 A2 B1 B2 C1 C2 ZN VDD VNW VPW VSS
.ends

* Black-box entry subcircuit for gf180mcu_fd_sc_mcu7t5v0__aoi22_2 abstract view
.subckt gf180mcu_fd_sc_mcu7t5v0__aoi22_2 A1 A2 B1 B2 ZN VDD VNW VPW VSS
.ends

* Black-box entry subcircuit for gf180mcu_fd_sc_mcu7t5v0__aoi221_1 abstract view
.subckt gf180mcu_fd_sc_mcu7t5v0__aoi221_1 A1 A2 B1 B2 C ZN VDD VNW VPW VSS
.ends

.subckt tt_um_transmit_5_3 B[0] B[1] B[2] B[3] B[4] T[0] T[1] T[2] T[3] T[4] T[5]
+ T[6] VGND VPWR clk enable in rst_n
XFILLER_22_177 VPWR VPWR VGND VGND gf180mcu_fd_sc_mcu7t5v0__fillcap_4
X_432_ _387_/Z _420_/Z _432_/Z VPWR VPWR VGND VGND gf180mcu_fd_sc_mcu7t5v0__or2_1
Xwire18 wire18/I _471_/B VPWR VPWR VGND VGND gf180mcu_fd_sc_mcu7t5v0__clkbuf_1
XPHY_EDGE_ROW_37_Left_86 VPWR VGND gf180mcu_fd_sc_mcu7t5v0__endcap
X_501_ _504_/A2 _501_/A2 _501_/A3 _501_/B _511_/A2 VPWR VPWR VGND VGND gf180mcu_fd_sc_mcu7t5v0__oai31_1
X_363_ _363_/A1 _515_/C _496_/B2 VPWR VPWR VGND VGND gf180mcu_fd_sc_mcu7t5v0__nor2_4
XTAP_TAPCELL_ROW_15_139 VPWR VGND gf180mcu_fd_sc_mcu7t5v0__filltie
XFILLER_8_181 VPWR VPWR VGND VGND gf180mcu_fd_sc_mcu7t5v0__fill_1
X_415_ _392_/Z _321_/Z _415_/A3 _526_/B1 VPWR VPWR VGND VGND gf180mcu_fd_sc_mcu7t5v0__nor3_4
XFILLER_6_107 VPWR VPWR VGND VGND gf180mcu_fd_sc_mcu7t5v0__fillcap_64
XFILLER_10_103 VPWR VPWR VGND VGND gf180mcu_fd_sc_mcu7t5v0__fill_2
X_346_ _346_/A1 _336_/Z _346_/B _505_/A2 VPWR VPWR VGND VGND gf180mcu_fd_sc_mcu7t5v0__oai21_4
XFILLER_43_2 VPWR VPWR VGND VGND gf180mcu_fd_sc_mcu7t5v0__fill_2
XPHY_EDGE_ROW_24_Left_73 VPWR VGND gf180mcu_fd_sc_mcu7t5v0__endcap
X_329_ _378_/A1 _330_/A2 _329_/Z VPWR VPWR VGND VGND gf180mcu_fd_sc_mcu7t5v0__xor2_1
XFILLER_37_150 VPWR VPWR VGND VGND gf180mcu_fd_sc_mcu7t5v0__fill_2
Xload_slew30 _374_/A3 _482_/A1 VPWR VPWR VGND VGND gf180mcu_fd_sc_mcu7t5v0__buf_4
X_594_ _592_/Z _605_/A2 _596_/A2 VPWR VPWR VGND VGND gf180mcu_fd_sc_mcu7t5v0__xnor2_1
XFILLER_6_34 VPWR VPWR VGND VGND gf180mcu_fd_sc_mcu7t5v0__fill_1
XPHY_EDGE_ROW_11_Left_60 VPWR VGND gf180mcu_fd_sc_mcu7t5v0__endcap
X_577_ _581_/A1 _589_/A2 _577_/Z VPWR VPWR VGND VGND gf180mcu_fd_sc_mcu7t5v0__xor2_1
X_431_ _412_/B _519_/A3 _486_/B _431_/B2 _531_/A1 VPWR VPWR VGND VGND gf180mcu_fd_sc_mcu7t5v0__aoi22_4
X_500_ _388_/B _500_/A2 _500_/B _510_/A2 VPWR VPWR VGND VGND gf180mcu_fd_sc_mcu7t5v0__oai21_1
XFILLER_26_75 VPWR VPWR VGND VGND gf180mcu_fd_sc_mcu7t5v0__fillcap_4
XFILLER_26_42 VPWR VPWR VGND VGND gf180mcu_fd_sc_mcu7t5v0__fill_1
X_362_ _515_/A2 _480_/A2 _515_/C VPWR VPWR VGND VGND gf180mcu_fd_sc_mcu7t5v0__nand2_2
XFILLER_8_171 VPWR VPWR VGND VGND gf180mcu_fd_sc_mcu7t5v0__fillcap_4
XFILLER_37_96 VPWR VPWR VGND VGND gf180mcu_fd_sc_mcu7t5v0__fill_1
X_345_ _369_/B _533_/C _340_/Z _377_/B _310_/Z _391_/A4 VPWR VPWR VGND VGND gf180mcu_fd_sc_mcu7t5v0__oai32_4
X_414_ _338_/Z _533_/A2 _515_/B _538_/A3 VPWR VPWR VGND VGND gf180mcu_fd_sc_mcu7t5v0__oai21_4
XFILLER_5_174 VPWR VPWR VGND VGND gf180mcu_fd_sc_mcu7t5v0__fillcap_8
XPHY_EDGE_ROW_21_Right_21 VPWR VGND gf180mcu_fd_sc_mcu7t5v0__endcap
XPHY_EDGE_ROW_12_Right_12 VPWR VGND gf180mcu_fd_sc_mcu7t5v0__endcap
XPHY_EDGE_ROW_30_Right_30 VPWR VGND gf180mcu_fd_sc_mcu7t5v0__endcap
X_328_ _328_/A1 _568_/A1 _328_/B _330_/A2 VPWR VPWR VGND VGND gf180mcu_fd_sc_mcu7t5v0__oai21_1
XFILLER_3_2 VPWR VPWR VGND VGND gf180mcu_fd_sc_mcu7t5v0__fillcap_64
XFILLER_2_177 VPWR VPWR VGND VGND gf180mcu_fd_sc_mcu7t5v0__fillcap_4
XFILLER_0_36 VPWR VPWR VGND VGND gf180mcu_fd_sc_mcu7t5v0__fillcap_32
XFILLER_9_34 VPWR VPWR VGND VGND gf180mcu_fd_sc_mcu7t5v0__fillcap_16
XFILLER_36_2 VPWR VPWR VGND VGND gf180mcu_fd_sc_mcu7t5v0__fill_2
XFILLER_47_129 VPWR VPWR VGND VGND gf180mcu_fd_sc_mcu7t5v0__fill_1
XPHY_EDGE_ROW_41_Left_90 VPWR VGND gf180mcu_fd_sc_mcu7t5v0__endcap
XFILLER_34_86 VPWR VPWR VGND VGND gf180mcu_fd_sc_mcu7t5v0__fillcap_4
XFILLER_18_32 VPWR VPWR VGND VGND gf180mcu_fd_sc_mcu7t5v0__fill_2
XFILLER_46_173 VPWR VPWR VGND VGND gf180mcu_fd_sc_mcu7t5v0__fill_2
Xload_slew20 _324_/A1 _415_/A3 VPWR VPWR VGND VGND gf180mcu_fd_sc_mcu7t5v0__buf_2
Xload_slew31 _378_/A3 _374_/A3 VPWR VPWR VGND VGND gf180mcu_fd_sc_mcu7t5v0__buf_4
XFILLER_29_118 VPWR VPWR VGND VGND gf180mcu_fd_sc_mcu7t5v0__fill_1
XFILLER_37_173 VPWR VPWR VGND VGND gf180mcu_fd_sc_mcu7t5v0__fillcap_8
XFILLER_20_33 VPWR VPWR VGND VGND gf180mcu_fd_sc_mcu7t5v0__fill_2
XFILLER_45_30 VPWR VPWR VGND VGND gf180mcu_fd_sc_mcu7t5v0__fill_2
X_593_ _577_/Z _593_/A2 _593_/B _605_/A2 VPWR VPWR VGND VGND gf180mcu_fd_sc_mcu7t5v0__aoi21_1
XPHY_EDGE_ROW_6_Right_6 VPWR VGND gf180mcu_fd_sc_mcu7t5v0__endcap
XFILLER_31_32 VPWR VPWR VGND VGND gf180mcu_fd_sc_mcu7t5v0__fill_2
X_576_ _619_/Q _576_/A2 _620_/Q _581_/A2 VPWR VPWR VGND VGND gf180mcu_fd_sc_mcu7t5v0__oai21_1
X_430_ _430_/I _456_/A1 VPWR VPWR VGND VGND gf180mcu_fd_sc_mcu7t5v0__clkinv_8
X_361_ _505_/A1 _500_/A2 _495_/A2 VPWR VPWR VGND VGND gf180mcu_fd_sc_mcu7t5v0__nor2_2
XFILLER_9_139 VPWR VPWR VGND VGND gf180mcu_fd_sc_mcu7t5v0__fill_1
X_559_ _614_/Q _615_/Q _569_/A2 VPWR VPWR VGND VGND gf180mcu_fd_sc_mcu7t5v0__nor2_1
X_413_ _338_/Z _533_/A2 _526_/A3 VPWR VPWR VGND VGND gf180mcu_fd_sc_mcu7t5v0__nor2_2
X_344_ _344_/A1 _474_/B _471_/B _504_/A2 _518_/A1 VPWR VPWR VGND VGND gf180mcu_fd_sc_mcu7t5v0__aoi22_1
XFILLER_5_142 VPWR VPWR VGND VGND gf180mcu_fd_sc_mcu7t5v0__fillcap_32
XFILLER_2_101 VPWR VPWR VGND VGND gf180mcu_fd_sc_mcu7t5v0__fillcap_4
XFILLER_43_4 VPWR VPWR VGND VGND gf180mcu_fd_sc_mcu7t5v0__fill_1
X_327_ _415_/A3 _420_/A2 _321_/Z _369_/B VPWR VPWR VGND VGND gf180mcu_fd_sc_mcu7t5v0__or3_2
XFILLER_29_2 VPWR VPWR VGND VGND gf180mcu_fd_sc_mcu7t5v0__fill_1
XFILLER_34_98 VPWR VPWR VGND VGND gf180mcu_fd_sc_mcu7t5v0__fillcap_4
XFILLER_34_32 VPWR VPWR VGND VGND gf180mcu_fd_sc_mcu7t5v0__fill_2
Xload_slew43 _431_/B2 wire42/I VPWR VPWR VGND VGND gf180mcu_fd_sc_mcu7t5v0__buf_2
Xload_slew21 _364_/A1 _527_/A2 VPWR VPWR VGND VGND gf180mcu_fd_sc_mcu7t5v0__buf_2
Xload_slew32 _364_/C _378_/A3 VPWR VPWR VGND VGND gf180mcu_fd_sc_mcu7t5v0__buf_4
XFILLER_29_108 VPWR VPWR VGND VGND gf180mcu_fd_sc_mcu7t5v0__fillcap_8
XFILLER_45_86 VPWR VPWR VGND VGND gf180mcu_fd_sc_mcu7t5v0__fill_1
X_592_ _585_/B _590_/Z _592_/Z VPWR VPWR VGND VGND gf180mcu_fd_sc_mcu7t5v0__xor2_1
XFILLER_29_98 VPWR VPWR VGND VGND gf180mcu_fd_sc_mcu7t5v0__fill_2
XFILLER_34_177 VPWR VPWR VGND VGND gf180mcu_fd_sc_mcu7t5v0__fillcap_4
XFILLER_40_136 VPWR VPWR VGND VGND gf180mcu_fd_sc_mcu7t5v0__fillcap_4
X_575_ _575_/A1 _575_/A2 _575_/B _589_/A2 VPWR VPWR VGND VGND gf180mcu_fd_sc_mcu7t5v0__aoi21_2
XFILLER_31_136 VPWR VPWR VGND VGND gf180mcu_fd_sc_mcu7t5v0__fillcap_4
XFILLER_11_2 VPWR VPWR VGND VGND gf180mcu_fd_sc_mcu7t5v0__fillcap_16
XFILLER_16_177 VPWR VPWR VGND VGND gf180mcu_fd_sc_mcu7t5v0__fillcap_4
X_360_ _505_/A1 _485_/B2 _386_/A1 _498_/A3 VPWR VPWR VGND VGND gf180mcu_fd_sc_mcu7t5v0__nand3_4
X_489_ _504_/A2 _478_/B _497_/B VPWR VPWR VGND VGND gf180mcu_fd_sc_mcu7t5v0__nand2_1
X_558_ _615_/Q _558_/A2 _615_/D VPWR VPWR VGND VGND gf180mcu_fd_sc_mcu7t5v0__xor2_1
X_343_ _533_/C _340_/Z _504_/A2 VPWR VPWR VGND VGND gf180mcu_fd_sc_mcu7t5v0__nor2_1
X_412_ _412_/A1 _491_/A2 _412_/B _436_/A1 VPWR VPWR VGND VGND gf180mcu_fd_sc_mcu7t5v0__oai21_1
X_326_ _415_/A3 _420_/A2 _321_/Z wire18/I VPWR VPWR VGND VGND gf180mcu_fd_sc_mcu7t5v0__nor3_2
XFILLER_36_4 VPWR VPWR VGND VGND gf180mcu_fd_sc_mcu7t5v0__fill_1
XFILLER_34_22 VPWR VPWR VGND VGND gf180mcu_fd_sc_mcu7t5v0__fill_2
XFILLER_18_34 VPWR VPWR VGND VGND gf180mcu_fd_sc_mcu7t5v0__fill_1
Xload_slew44 _344_/A1 _431_/B2 VPWR VPWR VGND VGND gf180mcu_fd_sc_mcu7t5v0__buf_1
Xload_slew11 _496_/B1 _507_/A1 VPWR VPWR VGND VGND gf180mcu_fd_sc_mcu7t5v0__buf_2
X_309_ _621_/Q _568_/A1 _620_/Q _572_/A1 _496_/A1 VPWR VPWR VGND VGND gf180mcu_fd_sc_mcu7t5v0__nor4_4
XPHY_EDGE_ROW_28_Left_77 VPWR VGND gf180mcu_fd_sc_mcu7t5v0__endcap
Xload_slew22 _505_/A2 _364_/A1 VPWR VPWR VGND VGND gf180mcu_fd_sc_mcu7t5v0__buf_2
X_591_ _604_/B _590_/Z _597_/B VPWR VPWR VGND VGND gf180mcu_fd_sc_mcu7t5v0__nand2_1
XFILLER_45_32 VPWR VPWR VGND VGND gf180mcu_fd_sc_mcu7t5v0__fill_1
XFILLER_6_37 VPWR VPWR VGND VGND gf180mcu_fd_sc_mcu7t5v0__fillcap_64
XFILLER_15_35 VPWR VPWR VGND VGND gf180mcu_fd_sc_mcu7t5v0__fill_2
X_574_ _575_/B _574_/A2 _620_/D VPWR VPWR VGND VGND gf180mcu_fd_sc_mcu7t5v0__xor2_1
XFILLER_22_115 VPWR VPWR VGND VGND gf180mcu_fd_sc_mcu7t5v0__fill_1
XFILLER_13_115 VPWR VPWR VGND VGND gf180mcu_fd_sc_mcu7t5v0__fillcap_16
XPHY_EDGE_ROW_15_Left_64 VPWR VGND gf180mcu_fd_sc_mcu7t5v0__endcap
XFILLER_42_55 VPWR VPWR VGND VGND gf180mcu_fd_sc_mcu7t5v0__fillcap_4
X_626_ _626_/D _626_/RN _626_/CLK _626_/Q VPWR VPWR VGND VGND gf180mcu_fd_sc_mcu7t5v0__dffrnq_1
X_557_ _614_/Q _557_/A2 _614_/D VPWR VPWR VGND VGND gf180mcu_fd_sc_mcu7t5v0__xnor2_1
X_488_ _488_/A1 _525_/A1 _488_/A3 _488_/A4 _490_/A1 VPWR VPWR VGND VGND gf180mcu_fd_sc_mcu7t5v0__nor4_4
XFILLER_9_119 VPWR VPWR VGND VGND gf180mcu_fd_sc_mcu7t5v0__fillcap_16
XFILLER_10_107 VPWR VPWR VGND VGND gf180mcu_fd_sc_mcu7t5v0__fillcap_64
XFILLER_12_181 VPWR VPWR VGND VGND gf180mcu_fd_sc_mcu7t5v0__fill_1
X_411_ _439_/A2 _444_/B _446_/A4 VPWR VPWR VGND VGND gf180mcu_fd_sc_mcu7t5v0__nand2_1
XPHY_EDGE_ROW_0_Left_49 VPWR VGND gf180mcu_fd_sc_mcu7t5v0__endcap
X_342_ _515_/A2 _485_/B2 _386_/A1 _498_/A2 VPWR VPWR VGND VGND gf180mcu_fd_sc_mcu7t5v0__nand3_1
X_609_ _609_/A1 _607_/Z _609_/B _625_/D VPWR VPWR VGND VGND gf180mcu_fd_sc_mcu7t5v0__oai21_1
XFILLER_23_46 VPWR VPWR VGND VGND gf180mcu_fd_sc_mcu7t5v0__fill_2
XFILLER_23_13 VPWR VPWR VGND VGND gf180mcu_fd_sc_mcu7t5v0__fillcap_4
X_325_ _415_/A3 _492_/A1 _377_/B VPWR VPWR VGND VGND gf180mcu_fd_sc_mcu7t5v0__or2_2
Xload_slew45 _319_/A3 _316_/A1 VPWR VPWR VGND VGND gf180mcu_fd_sc_mcu7t5v0__buf_2
Xclkload0 _626_/CLK clkload0/Z VPWR VPWR VGND VGND gf180mcu_fd_sc_mcu7t5v0__clkbuf_2
XFILLER_34_34 VPWR VPWR VGND VGND gf180mcu_fd_sc_mcu7t5v0__fill_1
Xload_slew12 _501_/B _445_/A2 VPWR VPWR VGND VGND gf180mcu_fd_sc_mcu7t5v0__buf_2
XPHY_EDGE_ROW_3_Left_52 VPWR VGND gf180mcu_fd_sc_mcu7t5v0__endcap
XFILLER_1_2 VPWR VPWR VGND VGND gf180mcu_fd_sc_mcu7t5v0__fillcap_64
Xload_slew23 _394_/A3 _476_/S VPWR VPWR VGND VGND gf180mcu_fd_sc_mcu7t5v0__clkbuf_1
X_308_ _575_/B _378_/A2 _533_/B VPWR VPWR VGND VGND gf180mcu_fd_sc_mcu7t5v0__nand2_1
XPHY_EDGE_ROW_45_Left_94 VPWR VGND gf180mcu_fd_sc_mcu7t5v0__endcap
XFILLER_43_179 VPWR VPWR VGND VGND gf180mcu_fd_sc_mcu7t5v0__fill_2
X_590_ _623_/Q _598_/A3 _590_/Z VPWR VPWR VGND VGND gf180mcu_fd_sc_mcu7t5v0__xor2_1
XFILLER_34_102 VPWR VPWR VGND VGND gf180mcu_fd_sc_mcu7t5v0__fill_2
XFILLER_25_146 VPWR VPWR VGND VGND gf180mcu_fd_sc_mcu7t5v0__fill_2
X_573_ _619_/Q _576_/A2 _626_/Q _626_/D _574_/A2 VPWR VPWR VGND VGND gf180mcu_fd_sc_mcu7t5v0__oai211_1
XPHY_EDGE_ROW_28_Right_28 VPWR VGND gf180mcu_fd_sc_mcu7t5v0__endcap
XFILLER_16_168 VPWR VPWR VGND VGND gf180mcu_fd_sc_mcu7t5v0__fillcap_4
XPHY_EDGE_ROW_19_Right_19 VPWR VGND gf180mcu_fd_sc_mcu7t5v0__endcap
XPHY_EDGE_ROW_46_Right_46 VPWR VGND gf180mcu_fd_sc_mcu7t5v0__endcap
XPHY_EDGE_ROW_37_Right_37 VPWR VGND gf180mcu_fd_sc_mcu7t5v0__endcap
X_625_ _625_/D _625_/RN _626_/CLK _625_/Q VPWR VPWR VGND VGND gf180mcu_fd_sc_mcu7t5v0__dffrnq_2
XFILLER_42_34 VPWR VPWR VGND VGND gf180mcu_fd_sc_mcu7t5v0__fill_1
XTAP_TAPCELL_ROW_8_120 VPWR VGND gf180mcu_fd_sc_mcu7t5v0__filltie
XPHY_EDGE_ROW_32_Left_81 VPWR VGND gf180mcu_fd_sc_mcu7t5v0__endcap
X_487_ _487_/A1 _487_/A2 _488_/A4 VPWR VPWR VGND VGND gf180mcu_fd_sc_mcu7t5v0__nand2_1
X_556_ _614_/Q _557_/A2 _558_/A2 VPWR VPWR VGND VGND gf180mcu_fd_sc_mcu7t5v0__nor2_1
X_410_ _314_/Z _420_/A2 _464_/A2 _530_/A2 VPWR VPWR VGND VGND gf180mcu_fd_sc_mcu7t5v0__nor3_1
X_341_ _533_/C _338_/Z _519_/A3 VPWR VPWR VGND VGND gf180mcu_fd_sc_mcu7t5v0__nor2_2
XFILLER_12_26 VPWR VPWR VGND VGND gf180mcu_fd_sc_mcu7t5v0__fill_1
XFILLER_12_37 VPWR VPWR VGND VGND gf180mcu_fd_sc_mcu7t5v0__fill_2
X_608_ _625_/Q _609_/A1 _609_/B VPWR VPWR VGND VGND gf180mcu_fd_sc_mcu7t5v0__nand2_1
X_539_ _377_/B _387_/Z _539_/B _539_/C _540_/A2 VPWR VPWR VGND VGND gf180mcu_fd_sc_mcu7t5v0__oai211_1
X_324_ _324_/A1 _492_/A1 _412_/B VPWR VPWR VGND VGND gf180mcu_fd_sc_mcu7t5v0__nor2_4
Xload_slew13 _526_/B1 _501_/B VPWR VPWR VGND VGND gf180mcu_fd_sc_mcu7t5v0__buf_4
XFILLER_46_177 VPWR VPWR VGND VGND gf180mcu_fd_sc_mcu7t5v0__fillcap_4
XFILLER_37_122 VPWR VPWR VGND VGND gf180mcu_fd_sc_mcu7t5v0__fill_2
Xload_slew46 _344_/A1 _319_/A3 VPWR VPWR VGND VGND gf180mcu_fd_sc_mcu7t5v0__buf_2
XFILLER_27_2 VPWR VPWR VGND VGND gf180mcu_fd_sc_mcu7t5v0__fill_2
X_307_ _335_/B _346_/B _378_/A2 VPWR VPWR VGND VGND gf180mcu_fd_sc_mcu7t5v0__nor2_4
XFILLER_1_72 VPWR VPWR VGND VGND gf180mcu_fd_sc_mcu7t5v0__fillcap_64
XFILLER_28_177 VPWR VPWR VGND VGND gf180mcu_fd_sc_mcu7t5v0__fillcap_4
XFILLER_20_37 VPWR VPWR VGND VGND gf180mcu_fd_sc_mcu7t5v0__fillcap_4
XFILLER_34_125 VPWR VPWR VGND VGND gf180mcu_fd_sc_mcu7t5v0__fillcap_4
XFILLER_15_37 VPWR VPWR VGND VGND gf180mcu_fd_sc_mcu7t5v0__fill_1
X_572_ _572_/A1 _572_/A2 _619_/D VPWR VPWR VGND VGND gf180mcu_fd_sc_mcu7t5v0__xor2_1
XTAP_TAPCELL_ROW_8_121 VPWR VGND gf180mcu_fd_sc_mcu7t5v0__filltie
XFILLER_13_139 VPWR VPWR VGND VGND gf180mcu_fd_sc_mcu7t5v0__fill_1
X_624_ _624_/D _625_/RN _626_/CLK _624_/Q VPWR VPWR VGND VGND gf180mcu_fd_sc_mcu7t5v0__dffrnq_1
XTAP_TAPCELL_ROW_46_215 VPWR VGND gf180mcu_fd_sc_mcu7t5v0__filltie
XFILLER_32_90 VPWR VPWR VGND VGND gf180mcu_fd_sc_mcu7t5v0__fill_1
X_555_ _557_/A2 _555_/A2 _613_/D VPWR VPWR VGND VGND gf180mcu_fd_sc_mcu7t5v0__nand2_1
XFILLER_12_161 VPWR VPWR VGND VGND gf180mcu_fd_sc_mcu7t5v0__fillcap_8
X_486_ _486_/A1 _486_/A2 _486_/B _487_/A2 VPWR VPWR VGND VGND gf180mcu_fd_sc_mcu7t5v0__oai21_1
XFILLER_37_57 VPWR VPWR VGND VGND gf180mcu_fd_sc_mcu7t5v0__fill_2
XTAP_TAPCELL_ROW_5_113 VPWR VGND gf180mcu_fd_sc_mcu7t5v0__filltie
X_607_ _607_/A1 _606_/Z _607_/Z VPWR VPWR VGND VGND gf180mcu_fd_sc_mcu7t5v0__xor2_1
X_538_ _541_/A1 _541_/A2 _538_/A3 _538_/B _539_/C VPWR VPWR VGND VGND gf180mcu_fd_sc_mcu7t5v0__oai31_1
X_340_ _566_/A1 _346_/A1 _336_/Z _340_/Z VPWR VPWR VGND VGND gf180mcu_fd_sc_mcu7t5v0__or3_2
XFILLER_23_48 VPWR VPWR VGND VGND gf180mcu_fd_sc_mcu7t5v0__fill_1
XFILLER_23_26 VPWR VPWR VGND VGND gf180mcu_fd_sc_mcu7t5v0__fillcap_4
XTAP_TAPCELL_ROW_2_105 VPWR VGND gf180mcu_fd_sc_mcu7t5v0__filltie
X_469_ _469_/A1 _506_/B _469_/A3 _542_/A3 _525_/A1 VPWR VPWR VGND VGND gf180mcu_fd_sc_mcu7t5v0__nand4_2
X_323_ _599_/A1 _392_/A1 _323_/B1 _323_/B2 _323_/C _492_/A1 VPWR VPWR VGND VGND gf180mcu_fd_sc_mcu7t5v0__oai221_4
XFILLER_18_37 VPWR VPWR VGND VGND gf180mcu_fd_sc_mcu7t5v0__fillcap_4
X_306_ _585_/B _604_/B VPWR VPWR VGND VGND gf180mcu_fd_sc_mcu7t5v0__clkinv_1
Xload_slew36 _330_/Z _515_/A2 VPWR VPWR VGND VGND gf180mcu_fd_sc_mcu7t5v0__buf_4
Xload_slew25 _385_/A2 _351_/A1 VPWR VPWR VGND VGND gf180mcu_fd_sc_mcu7t5v0__buf_2
XTAP_TAPCELL_ROW_38_195 VPWR VGND gf180mcu_fd_sc_mcu7t5v0__filltie
XFILLER_34_104 VPWR VPWR VGND VGND gf180mcu_fd_sc_mcu7t5v0__fill_1
XTAP_TAPCELL_ROW_29_173 VPWR VGND gf180mcu_fd_sc_mcu7t5v0__filltie
XFILLER_42_181 VPWR VPWR VGND VGND gf180mcu_fd_sc_mcu7t5v0__fill_1
XFILLER_25_137 VPWR VPWR VGND VGND gf180mcu_fd_sc_mcu7t5v0__fill_2
X_571_ _561_/B _576_/A2 _572_/A2 VPWR VPWR VGND VGND gf180mcu_fd_sc_mcu7t5v0__nor2_1
XTAP_TAPCELL_ROW_26_165 VPWR VGND gf180mcu_fd_sc_mcu7t5v0__filltie
XFILLER_24_181 VPWR VPWR VGND VGND gf180mcu_fd_sc_mcu7t5v0__fill_1
XPHY_EDGE_ROW_1_Right_1 VPWR VGND gf180mcu_fd_sc_mcu7t5v0__endcap
XFILLER_16_104 VPWR VPWR VGND VGND gf180mcu_fd_sc_mcu7t5v0__fill_1
XFILLER_7_72 VPWR VPWR VGND VGND gf180mcu_fd_sc_mcu7t5v0__fillcap_64
XTAP_TAPCELL_ROW_17_143 VPWR VGND gf180mcu_fd_sc_mcu7t5v0__filltie
XTAP_TAPCELL_ROW_46_216 VPWR VGND gf180mcu_fd_sc_mcu7t5v0__filltie
X_623_ _623_/D _625_/RN _626_/CLK _623_/Q VPWR VPWR VGND VGND gf180mcu_fd_sc_mcu7t5v0__dffrnq_1
XFILLER_8_177 VPWR VPWR VGND VGND gf180mcu_fd_sc_mcu7t5v0__fillcap_4
XTAP_TAPCELL_ROW_8_122 VPWR VGND gf180mcu_fd_sc_mcu7t5v0__filltie
X_485_ _566_/A1 _533_/C _340_/Z _485_/B2 _485_/C _486_/A2 VPWR VPWR VGND VGND gf180mcu_fd_sc_mcu7t5v0__oai221_1
XFILLER_12_173 VPWR VPWR VGND VGND gf180mcu_fd_sc_mcu7t5v0__fill_2
XTAP_TAPCELL_ROW_14_135 VPWR VGND gf180mcu_fd_sc_mcu7t5v0__filltie
X_554_ _612_/Q _561_/B _548_/Z _613_/Q _555_/A2 VPWR VPWR VGND VGND gf180mcu_fd_sc_mcu7t5v0__oai31_1
XTAP_TAPCELL_ROW_5_114 VPWR VGND gf180mcu_fd_sc_mcu7t5v0__filltie
XFILLER_12_39 VPWR VPWR VGND VGND gf180mcu_fd_sc_mcu7t5v0__fill_1
XPHY_EDGE_ROW_19_Left_68 VPWR VGND gf180mcu_fd_sc_mcu7t5v0__endcap
XTAP_TAPCELL_ROW_43_208 VPWR VGND gf180mcu_fd_sc_mcu7t5v0__filltie
XFILLER_37_69 VPWR VPWR VGND VGND gf180mcu_fd_sc_mcu7t5v0__fill_1
XFILLER_5_136 VPWR VPWR VGND VGND gf180mcu_fd_sc_mcu7t5v0__fillcap_4
X_606_ _625_/Q _604_/B _606_/A3 _606_/Z VPWR VPWR VGND VGND gf180mcu_fd_sc_mcu7t5v0__xor3_1
X_537_ _537_/A1 _537_/A2 _540_/A1 VPWR VPWR VGND VGND gf180mcu_fd_sc_mcu7t5v0__nand2_1
XFILLER_27_91 VPWR VPWR VGND VGND gf180mcu_fd_sc_mcu7t5v0__fillcap_8
X_468_ _501_/A2 _478_/B _542_/A3 VPWR VPWR VGND VGND gf180mcu_fd_sc_mcu7t5v0__nand2_2
XTAP_TAPCELL_ROW_2_106 VPWR VGND gf180mcu_fd_sc_mcu7t5v0__filltie
X_399_ _538_/B _444_/A1 _427_/A1 VPWR VPWR VGND VGND gf180mcu_fd_sc_mcu7t5v0__nand2_1
X_322_ _323_/B1 _323_/B2 _464_/A2 VPWR VPWR VGND VGND gf180mcu_fd_sc_mcu7t5v0__nor2_2
XFILLER_23_38 VPWR VPWR VGND VGND gf180mcu_fd_sc_mcu7t5v0__fillcap_8
Xfanout50 _618_/Q _568_/A1 VPWR VPWR VGND VGND gf180mcu_fd_sc_mcu7t5v0__buf_4
X_305_ _624_/Q _599_/A1 VPWR VPWR VGND VGND gf180mcu_fd_sc_mcu7t5v0__inv_2
Xload_slew26 _381_/A3 _363_/A1 VPWR VPWR VGND VGND gf180mcu_fd_sc_mcu7t5v0__clkbuf_1
XFILLER_27_4 VPWR VPWR VGND VGND gf180mcu_fd_sc_mcu7t5v0__fill_1
XTAP_TAPCELL_ROW_38_196 VPWR VGND gf180mcu_fd_sc_mcu7t5v0__filltie
XPHY_EDGE_ROW_7_Left_56 VPWR VGND gf180mcu_fd_sc_mcu7t5v0__endcap
XFILLER_19_102 VPWR VPWR VGND VGND gf180mcu_fd_sc_mcu7t5v0__fill_2
XFILLER_32_2 VPWR VPWR VGND VGND gf180mcu_fd_sc_mcu7t5v0__fill_1
XTAP_TAPCELL_ROW_29_174 VPWR VGND gf180mcu_fd_sc_mcu7t5v0__filltie
XTAP_TAPCELL_ROW_35_188 VPWR VGND gf180mcu_fd_sc_mcu7t5v0__filltie
X_570_ _548_/Z _560_/Z _570_/B _575_/A2 VPWR VPWR VGND VGND gf180mcu_fd_sc_mcu7t5v0__oai21_1
Xclkbuf_0_clk clk clkbuf_0_clk/Z VPWR VPWR VGND VGND gf180mcu_fd_sc_mcu7t5v0__clkbuf_16
XTAP_TAPCELL_ROW_26_166 VPWR VGND gf180mcu_fd_sc_mcu7t5v0__filltie
XTAP_TAPCELL_ROW_17_144 VPWR VGND gf180mcu_fd_sc_mcu7t5v0__filltie
XPHY_EDGE_ROW_24_Right_24 VPWR VGND gf180mcu_fd_sc_mcu7t5v0__endcap
XTAP_TAPCELL_ROW_23_158 VPWR VGND gf180mcu_fd_sc_mcu7t5v0__filltie
XPHY_EDGE_ROW_15_Right_15 VPWR VGND gf180mcu_fd_sc_mcu7t5v0__endcap
XTAP_TAPCELL_ROW_46_217 VPWR VGND gf180mcu_fd_sc_mcu7t5v0__filltie
XPHY_EDGE_ROW_42_Right_42 VPWR VGND gf180mcu_fd_sc_mcu7t5v0__endcap
X_622_ _622_/D _625_/RN _626_/CLK _622_/Q VPWR VPWR VGND VGND gf180mcu_fd_sc_mcu7t5v0__dffrnq_1
XPHY_EDGE_ROW_33_Right_33 VPWR VGND gf180mcu_fd_sc_mcu7t5v0__endcap
X_553_ _626_/D _626_/Q _569_/A1 _557_/A2 VPWR VPWR VGND VGND gf180mcu_fd_sc_mcu7t5v0__nand3_1
XFILLER_8_101 VPWR VPWR VGND VGND gf180mcu_fd_sc_mcu7t5v0__fillcap_4
X_484_ _444_/B _484_/A2 _487_/A1 VPWR VPWR VGND VGND gf180mcu_fd_sc_mcu7t5v0__nand2_1
XTAP_TAPCELL_ROW_14_136 VPWR VGND gf180mcu_fd_sc_mcu7t5v0__filltie
XFILLER_12_18 VPWR VPWR VGND VGND gf180mcu_fd_sc_mcu7t5v0__fillcap_8
XTAP_TAPCELL_ROW_43_209 VPWR VGND gf180mcu_fd_sc_mcu7t5v0__filltie
XPHY_EDGE_ROW_36_Left_85 VPWR VGND gf180mcu_fd_sc_mcu7t5v0__endcap
XTAP_TAPCELL_ROW_11_128 VPWR VGND gf180mcu_fd_sc_mcu7t5v0__filltie
X_605_ _592_/Z _605_/A2 _600_/Z _605_/B _607_/A1 VPWR VPWR VGND VGND gf180mcu_fd_sc_mcu7t5v0__oai31_1
X_536_ wire8/Z _536_/A2 _531_/Z _535_/Z B[3] VPWR VPWR VGND VGND gf180mcu_fd_sc_mcu7t5v0__nand4_4
XFILLER_4_181 VPWR VPWR VGND VGND gf180mcu_fd_sc_mcu7t5v0__fill_1
XTAP_TAPCELL_ROW_2_107 VPWR VGND gf180mcu_fd_sc_mcu7t5v0__filltie
X_398_ _498_/A2 _483_/B _500_/B _398_/A4 _444_/A1 VPWR VPWR VGND VGND gf180mcu_fd_sc_mcu7t5v0__nand4_1
X_467_ _530_/B _486_/B _469_/A3 VPWR VPWR VGND VGND gf180mcu_fd_sc_mcu7t5v0__nand2_1
XPHY_EDGE_ROW_20_Left_69 VPWR VGND gf180mcu_fd_sc_mcu7t5v0__endcap
XFILLER_2_107 VPWR VPWR VGND VGND gf180mcu_fd_sc_mcu7t5v0__fillcap_64
X_321_ _323_/B1 _323_/B2 _321_/Z VPWR VPWR VGND VGND gf180mcu_fd_sc_mcu7t5v0__or2_2
Xfanout40 _545_/ZN _609_/A1 VPWR VPWR VGND VGND gf180mcu_fd_sc_mcu7t5v0__dlyb_1
Xfanout51 input3/Z _626_/RN VPWR VPWR VGND VGND gf180mcu_fd_sc_mcu7t5v0__dlyb_1
XFILLER_13_72 VPWR VPWR VGND VGND gf180mcu_fd_sc_mcu7t5v0__fillcap_4
X_519_ _532_/B2 _541_/A2 _519_/A3 _519_/A4 _519_/Z VPWR VPWR VGND VGND gf180mcu_fd_sc_mcu7t5v0__or4_2
XFILLER_18_28 VPWR VPWR VGND VGND gf180mcu_fd_sc_mcu7t5v0__fillcap_4
Xload_slew16 _401_/ZN _541_/B VPWR VPWR VGND VGND gf180mcu_fd_sc_mcu7t5v0__dlyb_1
X_304_ _622_/Q _581_/B VPWR VPWR VGND VGND gf180mcu_fd_sc_mcu7t5v0__clkinv_1
Xload_slew27 _348_/A2 _381_/A3 VPWR VPWR VGND VGND gf180mcu_fd_sc_mcu7t5v0__buf_4
XFILLER_37_136 VPWR VPWR VGND VGND gf180mcu_fd_sc_mcu7t5v0__fillcap_4
XPHY_EDGE_ROW_23_Left_72 VPWR VGND gf180mcu_fd_sc_mcu7t5v0__endcap
XFILLER_20_29 VPWR VPWR VGND VGND gf180mcu_fd_sc_mcu7t5v0__fillcap_4
XTAP_TAPCELL_ROW_38_197 VPWR VGND gf180mcu_fd_sc_mcu7t5v0__filltie
XFILLER_19_93 VPWR VPWR VGND VGND gf180mcu_fd_sc_mcu7t5v0__fill_1
XTAP_TAPCELL_ROW_35_189 VPWR VGND gf180mcu_fd_sc_mcu7t5v0__filltie
XFILLER_25_139 VPWR VPWR VGND VGND gf180mcu_fd_sc_mcu7t5v0__fill_1
XFILLER_25_2 VPWR VPWR VGND VGND gf180mcu_fd_sc_mcu7t5v0__fill_2
XFILLER_15_18 VPWR VPWR VGND VGND gf180mcu_fd_sc_mcu7t5v0__fillcap_8
XTAP_TAPCELL_ROW_26_167 VPWR VGND gf180mcu_fd_sc_mcu7t5v0__filltie
XFILLER_21_72 VPWR VPWR VGND VGND gf180mcu_fd_sc_mcu7t5v0__fill_1
XFILLER_16_128 VPWR VPWR VGND VGND gf180mcu_fd_sc_mcu7t5v0__fillcap_32
XFILLER_30_153 VPWR VPWR VGND VGND gf180mcu_fd_sc_mcu7t5v0__fill_2
X_552_ _610_/Q _611_/Q _612_/Q _613_/Q _569_/A1 VPWR VPWR VGND VGND gf180mcu_fd_sc_mcu7t5v0__aoi211_2
X_621_ _621_/D _625_/RN _626_/CLK _621_/Q VPWR VPWR VGND VGND gf180mcu_fd_sc_mcu7t5v0__dffrnq_2
XTAP_TAPCELL_ROW_23_159 VPWR VGND gf180mcu_fd_sc_mcu7t5v0__filltie
X_483_ _340_/Z _483_/A2 _483_/B _484_/A2 VPWR VPWR VGND VGND gf180mcu_fd_sc_mcu7t5v0__oai21_1
XTAP_TAPCELL_ROW_14_137 VPWR VGND gf180mcu_fd_sc_mcu7t5v0__filltie
XTAP_TAPCELL_ROW_11_129 VPWR VGND gf180mcu_fd_sc_mcu7t5v0__filltie
X_604_ _590_/Z _599_/Z _604_/B _605_/B VPWR VPWR VGND VGND gf180mcu_fd_sc_mcu7t5v0__oai21_1
X_535_ _535_/A1 _535_/A2 _535_/A3 _535_/A4 _535_/Z VPWR VPWR VGND VGND gf180mcu_fd_sc_mcu7t5v0__and4_1
X_397_ _483_/B _395_/Z _528_/A1 VPWR VPWR VGND VGND gf180mcu_fd_sc_mcu7t5v0__nand2_1
XFILLER_4_171 VPWR VPWR VGND VGND gf180mcu_fd_sc_mcu7t5v0__fillcap_4
X_466_ _480_/A2 _483_/A2 _532_/B1 _506_/B VPWR VPWR VGND VGND gf180mcu_fd_sc_mcu7t5v0__nand3_1
Xfanout52 input3/Z _625_/RN VPWR VPWR VGND VGND gf180mcu_fd_sc_mcu7t5v0__dlyb_1
X_320_ _328_/B _310_/Z _581_/B _323_/B2 VPWR VPWR VGND VGND gf180mcu_fd_sc_mcu7t5v0__aoi21_2
Xfanout41 _496_/A1 _344_/A1 VPWR VPWR VGND VGND gf180mcu_fd_sc_mcu7t5v0__buf_2
XFILLER_1_174 VPWR VPWR VGND VGND gf180mcu_fd_sc_mcu7t5v0__fillcap_8
XTAP_TAPCELL_ROW_0_98 VPWR VGND gf180mcu_fd_sc_mcu7t5v0__filltie
X_449_ _453_/A3 _454_/A2 T[0] VPWR VPWR VGND VGND gf180mcu_fd_sc_mcu7t5v0__nor2_4
X_518_ _518_/A1 _518_/A2 _525_/A4 VPWR VPWR VGND VGND gf180mcu_fd_sc_mcu7t5v0__nand2_1
XFILLER_18_18 VPWR VPWR VGND VGND gf180mcu_fd_sc_mcu7t5v0__fill_1
XFILLER_46_137 VPWR VPWR VGND VGND gf180mcu_fd_sc_mcu7t5v0__fill_2
Xload_slew28 _348_/A2 _385_/A2 VPWR VPWR VGND VGND gf180mcu_fd_sc_mcu7t5v0__buf_4
X_303_ _621_/Q _581_/A1 VPWR VPWR VGND VGND gf180mcu_fd_sc_mcu7t5v0__clkinv_1
XFILLER_36_181 VPWR VPWR VGND VGND gf180mcu_fd_sc_mcu7t5v0__fill_1
XFILLER_34_129 VPWR VPWR VGND VGND gf180mcu_fd_sc_mcu7t5v0__fill_1
XFILLER_10_52 VPWR VPWR VGND VGND gf180mcu_fd_sc_mcu7t5v0__fill_1
XFILLER_18_2 VPWR VPWR VGND VGND gf180mcu_fd_sc_mcu7t5v0__fillcap_16
XFILLER_18_181 VPWR VPWR VGND VGND gf180mcu_fd_sc_mcu7t5v0__fill_1
X_620_ _620_/D _626_/RN _620_/CLK _620_/Q VPWR VPWR VGND VGND gf180mcu_fd_sc_mcu7t5v0__dffrnq_4
X_551_ _612_/Q _551_/A2 _612_/D VPWR VPWR VGND VGND gf180mcu_fd_sc_mcu7t5v0__xor2_1
XPHY_EDGE_ROW_5_Right_5 VPWR VGND gf180mcu_fd_sc_mcu7t5v0__endcap
X_482_ _482_/A1 _340_/Z _506_/A2 _503_/B _482_/B2 _488_/A3 VPWR VPWR VGND VGND gf180mcu_fd_sc_mcu7t5v0__oai32_4
X_603_ _609_/A1 _601_/Z _603_/B _624_/D VPWR VPWR VGND VGND gf180mcu_fd_sc_mcu7t5v0__oai21_1
X_465_ _321_/Z _504_/B2 _503_/B VPWR VPWR VGND VGND gf180mcu_fd_sc_mcu7t5v0__nand2_1
X_534_ _534_/A1 _534_/A2 _534_/B _534_/C _535_/A4 VPWR VPWR VGND VGND gf180mcu_fd_sc_mcu7t5v0__aoi211_1
X_396_ _500_/B _398_/A4 _425_/A2 VPWR VPWR VGND VGND gf180mcu_fd_sc_mcu7t5v0__nand2_1
XFILLER_1_142 VPWR VPWR VGND VGND gf180mcu_fd_sc_mcu7t5v0__fillcap_32
X_448_ _448_/I _453_/A3 VPWR VPWR VGND VGND gf180mcu_fd_sc_mcu7t5v0__inv_1
XTAP_TAPCELL_ROW_0_99 VPWR VGND gf180mcu_fd_sc_mcu7t5v0__filltie
X_379_ _515_/A2 _485_/B2 _483_/A2 VPWR VPWR VGND VGND gf180mcu_fd_sc_mcu7t5v0__nor2_1
X_517_ _517_/A1 _517_/A2 _517_/A3 _517_/A4 _525_/A2 VPWR VPWR VGND VGND gf180mcu_fd_sc_mcu7t5v0__nand4_1
Xload_slew29 _482_/A1 _348_/A2 VPWR VPWR VGND VGND gf180mcu_fd_sc_mcu7t5v0__buf_4
X_302_ _620_/Q _575_/B VPWR VPWR VGND VGND gf180mcu_fd_sc_mcu7t5v0__clkinv_1
XFILLER_1_66 VPWR VPWR VGND VGND gf180mcu_fd_sc_mcu7t5v0__fillcap_4
XFILLER_29_18 VPWR VPWR VGND VGND gf180mcu_fd_sc_mcu7t5v0__fill_2
XFILLER_42_174 VPWR VPWR VGND VGND gf180mcu_fd_sc_mcu7t5v0__fill_1
XFILLER_35_72 VPWR VPWR VGND VGND gf180mcu_fd_sc_mcu7t5v0__fill_2
XFILLER_31_19 VPWR VPWR VGND VGND gf180mcu_fd_sc_mcu7t5v0__fill_2
XFILLER_25_4 VPWR VPWR VGND VGND gf180mcu_fd_sc_mcu7t5v0__fill_1
XFILLER_24_174 VPWR VPWR VGND VGND gf180mcu_fd_sc_mcu7t5v0__fill_1
XFILLER_30_155 VPWR VPWR VGND VGND gf180mcu_fd_sc_mcu7t5v0__fill_1
XFILLER_30_2 VPWR VPWR VGND VGND gf180mcu_fd_sc_mcu7t5v0__fill_2
XFILLER_15_174 VPWR VPWR VGND VGND gf180mcu_fd_sc_mcu7t5v0__fillcap_8
XFILLER_21_122 VPWR VPWR VGND VGND gf180mcu_fd_sc_mcu7t5v0__fill_2
X_550_ _561_/B _548_/Z _551_/A2 VPWR VPWR VGND VGND gf180mcu_fd_sc_mcu7t5v0__nor2_1
XPHY_EDGE_ROW_11_Right_11 VPWR VGND gf180mcu_fd_sc_mcu7t5v0__endcap
XFILLER_12_177 VPWR VPWR VGND VGND gf180mcu_fd_sc_mcu7t5v0__fillcap_4
XFILLER_16_41 VPWR VPWR VGND VGND gf180mcu_fd_sc_mcu7t5v0__fill_1
X_481_ _481_/A1 _532_/B2 _491_/A2 _482_/B2 VPWR VPWR VGND VGND gf180mcu_fd_sc_mcu7t5v0__nor3_2
XPHY_EDGE_ROW_20_Right_20 VPWR VGND gf180mcu_fd_sc_mcu7t5v0__endcap
X_464_ _314_/Z _464_/A2 _392_/Z _532_/B1 VPWR VPWR VGND VGND gf180mcu_fd_sc_mcu7t5v0__nor3_4
X_602_ _624_/Q _609_/A1 _603_/B VPWR VPWR VGND VGND gf180mcu_fd_sc_mcu7t5v0__nand2_1
X_533_ _338_/Z _533_/A2 _533_/B _533_/C _534_/A2 VPWR VPWR VGND VGND gf180mcu_fd_sc_mcu7t5v0__oai211_1
X_395_ _500_/B _398_/A4 _395_/Z VPWR VPWR VGND VGND gf180mcu_fd_sc_mcu7t5v0__and2_1
Xfanout10 _496_/B1 _486_/B VPWR VPWR VGND VGND gf180mcu_fd_sc_mcu7t5v0__buf_2
X_447_ _447_/A1 _447_/A2 _391_/Z _450_/A2 VPWR VPWR VGND VGND gf180mcu_fd_sc_mcu7t5v0__nor3_4
X_378_ _378_/A1 _378_/A2 _378_/A3 _493_/A2 VPWR VPWR VGND VGND gf180mcu_fd_sc_mcu7t5v0__nand3_4
XFILLER_8_2 VPWR VPWR VGND VGND gf180mcu_fd_sc_mcu7t5v0__fillcap_32
X_516_ _501_/B _516_/A2 _517_/A4 VPWR VPWR VGND VGND gf180mcu_fd_sc_mcu7t5v0__nand2_1
Xload_slew19 _412_/B _474_/B VPWR VPWR VGND VGND gf180mcu_fd_sc_mcu7t5v0__buf_2
X_301_ _346_/B _566_/A1 VPWR VPWR VGND VGND gf180mcu_fd_sc_mcu7t5v0__inv_2
XPHY_EDGE_ROW_27_Left_76 VPWR VGND gf180mcu_fd_sc_mcu7t5v0__endcap
XFILLER_7_66 VPWR VPWR VGND VGND gf180mcu_fd_sc_mcu7t5v0__fillcap_4
XFILLER_15_142 VPWR VPWR VGND VGND gf180mcu_fd_sc_mcu7t5v0__fillcap_32
XFILLER_23_2 VPWR VPWR VGND VGND gf180mcu_fd_sc_mcu7t5v0__fill_2
XFILLER_12_145 VPWR VPWR VGND VGND gf180mcu_fd_sc_mcu7t5v0__fillcap_16
XFILLER_16_86 VPWR VPWR VGND VGND gf180mcu_fd_sc_mcu7t5v0__fill_2
X_480_ _533_/A2 _480_/A2 _481_/A1 VPWR VPWR VGND VGND gf180mcu_fd_sc_mcu7t5v0__nor2_1
X_601_ _601_/A1 _600_/Z _601_/Z VPWR VPWR VGND VGND gf180mcu_fd_sc_mcu7t5v0__xor2_1
XPHY_EDGE_ROW_14_Left_63 VPWR VGND gf180mcu_fd_sc_mcu7t5v0__endcap
Xload_slew6 _448_/I _456_/A3 VPWR VPWR VGND VGND gf180mcu_fd_sc_mcu7t5v0__buf_4
X_532_ _532_/A1 _478_/B _532_/B1 _532_/B2 _535_/A3 VPWR VPWR VGND VGND gf180mcu_fd_sc_mcu7t5v0__aoi22_1
XFILLER_4_34 VPWR VPWR VGND VGND gf180mcu_fd_sc_mcu7t5v0__fill_1
X_394_ _505_/A1 _485_/B2 _394_/A3 _398_/A4 VPWR VPWR VGND VGND gf180mcu_fd_sc_mcu7t5v0__nand3_1
X_463_ _444_/B _463_/A2 _469_/A1 VPWR VPWR VGND VGND gf180mcu_fd_sc_mcu7t5v0__nand2_1
Xfanout33 _333_/Z _388_/B VPWR VPWR VGND VGND gf180mcu_fd_sc_mcu7t5v0__buf_1
X_377_ _485_/C _509_/A2 _377_/B _534_/C VPWR VPWR VGND VGND gf180mcu_fd_sc_mcu7t5v0__aoi21_1
X_446_ _446_/A1 _446_/A2 _446_/A3 _446_/A4 _447_/A1 VPWR VPWR VGND VGND gf180mcu_fd_sc_mcu7t5v0__nand4_1
X_515_ _566_/A1 _515_/A2 _515_/B _515_/C _516_/A2 VPWR VPWR VGND VGND gf180mcu_fd_sc_mcu7t5v0__oai211_1
XFILLER_39_181 VPWR VPWR VGND VGND gf180mcu_fd_sc_mcu7t5v0__fill_1
XFILLER_24_53 VPWR VPWR VGND VGND gf180mcu_fd_sc_mcu7t5v0__fill_2
X_300_ _335_/B _575_/A1 VPWR VPWR VGND VGND gf180mcu_fd_sc_mcu7t5v0__clkinv_1
X_429_ _429_/A1 _543_/A1 _429_/A3 _391_/Z _430_/I VPWR VPWR VGND VGND gf180mcu_fd_sc_mcu7t5v0__or4_4
Xinput1 enable _626_/D VPWR VPWR VGND VGND gf180mcu_fd_sc_mcu7t5v0__dlyb_1
XFILLER_10_44 VPWR VPWR VGND VGND gf180mcu_fd_sc_mcu7t5v0__fill_1
XFILLER_10_99 VPWR VPWR VGND VGND gf180mcu_fd_sc_mcu7t5v0__fillcap_4
XPHY_EDGE_ROW_2_Left_51 VPWR VGND gf180mcu_fd_sc_mcu7t5v0__endcap
XFILLER_18_173 VPWR VPWR VGND VGND gf180mcu_fd_sc_mcu7t5v0__fill_2
XPHY_EDGE_ROW_44_Left_93 VPWR VGND gf180mcu_fd_sc_mcu7t5v0__endcap
XFILLER_21_21 VPWR VPWR VGND VGND gf180mcu_fd_sc_mcu7t5v0__fill_1
XFILLER_21_124 VPWR VPWR VGND VGND gf180mcu_fd_sc_mcu7t5v0__fill_1
XFILLER_16_2 VPWR VPWR VGND VGND gf180mcu_fd_sc_mcu7t5v0__fillcap_32
XFILLER_12_113 VPWR VPWR VGND VGND gf180mcu_fd_sc_mcu7t5v0__fillcap_32
XPHY_EDGE_ROW_9_Right_9 VPWR VGND gf180mcu_fd_sc_mcu7t5v0__endcap
X_600_ _585_/B _599_/Z _600_/Z VPWR VPWR VGND VGND gf180mcu_fd_sc_mcu7t5v0__xor2_1
X_393_ _415_/A3 _464_/A2 _392_/Z _534_/A1 VPWR VPWR VGND VGND gf180mcu_fd_sc_mcu7t5v0__nor3_2
X_531_ _531_/A1 _537_/A2 _531_/A3 _531_/Z VPWR VPWR VGND VGND gf180mcu_fd_sc_mcu7t5v0__and3_1
Xload_slew7 _450_/A2 _448_/I VPWR VPWR VGND VGND gf180mcu_fd_sc_mcu7t5v0__buf_4
XPHY_EDGE_ROW_31_Left_80 VPWR VGND gf180mcu_fd_sc_mcu7t5v0__endcap
X_462_ _527_/B1 _493_/A2 _505_/B _463_/A2 VPWR VPWR VGND VGND gf180mcu_fd_sc_mcu7t5v0__nand3_1
Xfanout34 _332_/Z _485_/B2 VPWR VPWR VGND VGND gf180mcu_fd_sc_mcu7t5v0__buf_3
X_514_ _538_/B _514_/A2 _514_/B _517_/A3 VPWR VPWR VGND VGND gf180mcu_fd_sc_mcu7t5v0__aoi21_1
X_376_ _501_/A2 _376_/A2 _509_/A2 VPWR VPWR VGND VGND gf180mcu_fd_sc_mcu7t5v0__nor2_1
X_445_ wire42/I _445_/A2 _486_/B _446_/A1 VPWR VPWR VGND VGND gf180mcu_fd_sc_mcu7t5v0__aoi21_1
XFILLER_45_130 VPWR VPWR VGND VGND gf180mcu_fd_sc_mcu7t5v0__fill_2
X_428_ _428_/A1 _436_/A1 _428_/A3 _440_/A1 _429_/A1 VPWR VPWR VGND VGND gf180mcu_fd_sc_mcu7t5v0__nand4_1
X_359_ _330_/Z _388_/B _338_/Z _541_/A2 VPWR VPWR VGND VGND gf180mcu_fd_sc_mcu7t5v0__nor3_4
Xinput2 in _585_/B VPWR VPWR VGND VGND gf180mcu_fd_sc_mcu7t5v0__dlyb_1
XFILLER_46_2 VPWR VPWR VGND VGND gf180mcu_fd_sc_mcu7t5v0__fill_2
XFILLER_10_34 VPWR VPWR VGND VGND gf180mcu_fd_sc_mcu7t5v0__fill_1
XFILLER_42_177 VPWR VPWR VGND VGND gf180mcu_fd_sc_mcu7t5v0__fillcap_4
XFILLER_24_177 VPWR VPWR VGND VGND gf180mcu_fd_sc_mcu7t5v0__fillcap_4
XTAP_TAPCELL_ROW_48_220 VPWR VGND gf180mcu_fd_sc_mcu7t5v0__filltie
XFILLER_30_103 VPWR VPWR VGND VGND gf180mcu_fd_sc_mcu7t5v0__fill_2
XFILLER_8_107 VPWR VPWR VGND VGND gf180mcu_fd_sc_mcu7t5v0__fillcap_64
XFILLER_12_169 VPWR VPWR VGND VGND gf180mcu_fd_sc_mcu7t5v0__fillcap_4
X_530_ _534_/A1 _530_/A2 _530_/B _531_/A3 VPWR VPWR VGND VGND gf180mcu_fd_sc_mcu7t5v0__oai21_1
X_392_ _392_/A1 _599_/A1 _392_/Z VPWR VPWR VGND VGND gf180mcu_fd_sc_mcu7t5v0__xor2_2
XTAP_TAPCELL_ROW_4_110 VPWR VGND gf180mcu_fd_sc_mcu7t5v0__filltie
X_461_ wire42/Z _461_/A2 _474_/B _490_/A3 VPWR VPWR VGND VGND gf180mcu_fd_sc_mcu7t5v0__oai21_1
Xfanout24 _333_/Z _364_/C VPWR VPWR VGND VGND gf180mcu_fd_sc_mcu7t5v0__buf_2
X_375_ _515_/B _475_/A2 _521_/B2 VPWR VPWR VGND VGND gf180mcu_fd_sc_mcu7t5v0__nand2_1
X_444_ _444_/A1 _444_/A2 _538_/A3 _444_/B _446_/A3 VPWR VPWR VGND VGND gf180mcu_fd_sc_mcu7t5v0__oai31_2
X_513_ _483_/B _500_/B _485_/C _505_/B _514_/A2 VPWR VPWR VGND VGND gf180mcu_fd_sc_mcu7t5v0__nand4_1
X_358_ _335_/B _566_/A1 _500_/A2 VPWR VPWR VGND VGND gf180mcu_fd_sc_mcu7t5v0__nand2_1
X_427_ _427_/A1 _517_/A1 _446_/A4 _429_/A3 VPWR VPWR VGND VGND gf180mcu_fd_sc_mcu7t5v0__nand3_1
XFILLER_24_55 VPWR VPWR VGND VGND gf180mcu_fd_sc_mcu7t5v0__fill_1
XFILLER_6_2 VPWR VPWR VGND VGND gf180mcu_fd_sc_mcu7t5v0__fillcap_32
Xinput3 rst_n input3/Z VPWR VPWR VGND VGND gf180mcu_fd_sc_mcu7t5v0__dlyb_1
XPHY_EDGE_ROW_27_Right_27 VPWR VGND gf180mcu_fd_sc_mcu7t5v0__endcap
XPHY_EDGE_ROW_18_Right_18 VPWR VGND gf180mcu_fd_sc_mcu7t5v0__endcap
XPHY_EDGE_ROW_45_Right_45 VPWR VGND gf180mcu_fd_sc_mcu7t5v0__endcap
XFILLER_42_112 VPWR VPWR VGND VGND gf180mcu_fd_sc_mcu7t5v0__fill_2
XPHY_EDGE_ROW_36_Right_36 VPWR VGND gf180mcu_fd_sc_mcu7t5v0__endcap
XFILLER_35_54 VPWR VPWR VGND VGND gf180mcu_fd_sc_mcu7t5v0__fillcap_4
XFILLER_27_142 VPWR VPWR VGND VGND gf180mcu_fd_sc_mcu7t5v0__fill_1
XFILLER_10_79 VPWR VPWR VGND VGND gf180mcu_fd_sc_mcu7t5v0__fill_2
XTAP_TAPCELL_ROW_28_170 VPWR VGND gf180mcu_fd_sc_mcu7t5v0__filltie
XTAP_TAPCELL_ROW_48_221 VPWR VGND gf180mcu_fd_sc_mcu7t5v0__filltie
XFILLER_15_134 VPWR VPWR VGND VGND gf180mcu_fd_sc_mcu7t5v0__fillcap_4
XFILLER_21_137 VPWR VPWR VGND VGND gf180mcu_fd_sc_mcu7t5v0__fill_2
XFILLER_16_34 VPWR VPWR VGND VGND gf180mcu_fd_sc_mcu7t5v0__fill_1
XTAP_TAPCELL_ROW_16_140 VPWR VGND gf180mcu_fd_sc_mcu7t5v0__filltie
XTAP_TAPCELL_ROW_45_213 VPWR VGND gf180mcu_fd_sc_mcu7t5v0__filltie
XFILLER_32_88 VPWR VPWR VGND VGND gf180mcu_fd_sc_mcu7t5v0__fill_2
XPHY_EDGE_ROW_0_Right_0 VPWR VGND gf180mcu_fd_sc_mcu7t5v0__endcap
XFILLER_12_104 VPWR VPWR VGND VGND gf180mcu_fd_sc_mcu7t5v0__fill_1
XFILLER_20_181 VPWR VPWR VGND VGND gf180mcu_fd_sc_mcu7t5v0__fill_1
XFILLER_7_174 VPWR VPWR VGND VGND gf180mcu_fd_sc_mcu7t5v0__fillcap_8
XFILLER_21_2 VPWR VPWR VGND VGND gf180mcu_fd_sc_mcu7t5v0__fill_1
XTAP_TAPCELL_ROW_42_205 VPWR VGND gf180mcu_fd_sc_mcu7t5v0__filltie
X_391_ _391_/A1 _534_/B _534_/C _391_/A4 _391_/Z VPWR VPWR VGND VGND gf180mcu_fd_sc_mcu7t5v0__or4_4
XFILLER_27_99 VPWR VPWR VGND VGND gf180mcu_fd_sc_mcu7t5v0__fillcap_4
XFILLER_27_66 VPWR VPWR VGND VGND gf180mcu_fd_sc_mcu7t5v0__fillcap_4
X_460_ wire42/Z _530_/B _478_/B _490_/A2 VPWR VPWR VGND VGND gf180mcu_fd_sc_mcu7t5v0__oai21_1
XTAP_TAPCELL_ROW_4_111 VPWR VGND gf180mcu_fd_sc_mcu7t5v0__filltie
X_589_ _621_/Q _589_/A2 _623_/Q _622_/Q _599_/A2 VPWR VPWR VGND VGND gf180mcu_fd_sc_mcu7t5v0__oai211_1
XFILLER_4_177 VPWR VPWR VGND VGND gf180mcu_fd_sc_mcu7t5v0__fillcap_4
XFILLER_4_37 VPWR VPWR VGND VGND gf180mcu_fd_sc_mcu7t5v0__fillcap_64
Xfanout14 _530_/A2 _444_/B VPWR VPWR VGND VGND gf180mcu_fd_sc_mcu7t5v0__buf_2
Xfanout47 _625_/Q _331_/B VPWR VPWR VGND VGND gf180mcu_fd_sc_mcu7t5v0__buf_4
XFILLER_1_136 VPWR VPWR VGND VGND gf180mcu_fd_sc_mcu7t5v0__fillcap_4
XTAP_TAPCELL_ROW_1_103 VPWR VGND gf180mcu_fd_sc_mcu7t5v0__filltie
XFILLER_13_68 VPWR VPWR VGND VGND gf180mcu_fd_sc_mcu7t5v0__fill_2
XPHY_EDGE_ROW_18_Left_67 VPWR VGND gf180mcu_fd_sc_mcu7t5v0__endcap
X_443_ _444_/A2 _444_/B _542_/A2 VPWR VPWR VGND VGND gf180mcu_fd_sc_mcu7t5v0__nand2_1
X_512_ _512_/A1 _511_/Z _512_/A3 B[1] VPWR VPWR VGND VGND gf180mcu_fd_sc_mcu7t5v0__nand3_4
X_374_ _568_/A1 _330_/Z _374_/A3 _338_/Z _475_/A2 VPWR VPWR VGND VGND gf180mcu_fd_sc_mcu7t5v0__nand4_4
XFILLER_0_180 VPWR VPWR VGND VGND gf180mcu_fd_sc_mcu7t5v0__fill_2
X_426_ _446_/A2 _426_/A2 _543_/A1 VPWR VPWR VGND VGND gf180mcu_fd_sc_mcu7t5v0__nand2_1
X_357_ _575_/A1 _346_/B _480_/A2 VPWR VPWR VGND VGND gf180mcu_fd_sc_mcu7t5v0__nor2_4
XTAP_TAPCELL_ROW_37_193 VPWR VGND gf180mcu_fd_sc_mcu7t5v0__filltie
XFILLER_35_66 VPWR VPWR VGND VGND gf180mcu_fd_sc_mcu7t5v0__fillcap_4
XFILLER_19_34 VPWR VPWR VGND VGND gf180mcu_fd_sc_mcu7t5v0__fillcap_4
XFILLER_19_67 VPWR VPWR VGND VGND gf180mcu_fd_sc_mcu7t5v0__fill_2
X_409_ _314_/Z _420_/A2 _508_/A1 VPWR VPWR VGND VGND gf180mcu_fd_sc_mcu7t5v0__nor2_1
XTAP_TAPCELL_ROW_28_171 VPWR VGND gf180mcu_fd_sc_mcu7t5v0__filltie
XTAP_TAPCELL_ROW_34_185 VPWR VGND gf180mcu_fd_sc_mcu7t5v0__filltie
XTAP_TAPCELL_ROW_25_163 VPWR VGND gf180mcu_fd_sc_mcu7t5v0__filltie
XPHY_EDGE_ROW_6_Left_55 VPWR VGND gf180mcu_fd_sc_mcu7t5v0__endcap
XTAP_TAPCELL_ROW_48_222 VPWR VGND gf180mcu_fd_sc_mcu7t5v0__filltie
XPHY_EDGE_ROW_48_Left_97 VPWR VGND gf180mcu_fd_sc_mcu7t5v0__endcap
XTAP_TAPCELL_ROW_16_141 VPWR VGND gf180mcu_fd_sc_mcu7t5v0__filltie
XTAP_TAPCELL_ROW_22_155 VPWR VGND gf180mcu_fd_sc_mcu7t5v0__filltie
XFILLER_16_57 VPWR VPWR VGND VGND gf180mcu_fd_sc_mcu7t5v0__fill_2
XTAP_TAPCELL_ROW_45_214 VPWR VGND gf180mcu_fd_sc_mcu7t5v0__filltie
XFILLER_7_142 VPWR VPWR VGND VGND gf180mcu_fd_sc_mcu7t5v0__fillcap_32
XTAP_TAPCELL_ROW_13_133 VPWR VGND gf180mcu_fd_sc_mcu7t5v0__filltie
XFILLER_14_2 VPWR VPWR VGND VGND gf180mcu_fd_sc_mcu7t5v0__fillcap_16
XTAP_TAPCELL_ROW_42_206 VPWR VGND gf180mcu_fd_sc_mcu7t5v0__filltie
X_390_ _377_/B _387_/Z _390_/B1 _369_/B _391_/A1 VPWR VPWR VGND VGND gf180mcu_fd_sc_mcu7t5v0__oai22_2
XTAP_TAPCELL_ROW_4_112 VPWR VGND gf180mcu_fd_sc_mcu7t5v0__filltie
X_588_ _561_/B _587_/Z _588_/B _622_/D VPWR VPWR VGND VGND gf180mcu_fd_sc_mcu7t5v0__oai21_1
XFILLER_4_101 VPWR VPWR VGND VGND gf180mcu_fd_sc_mcu7t5v0__fillcap_4
XTAP_TAPCELL_ROW_10_125 VPWR VGND gf180mcu_fd_sc_mcu7t5v0__filltie
Xfanout15 _401_/ZN _478_/B VPWR VPWR VGND VGND gf180mcu_fd_sc_mcu7t5v0__buf_3
Xfanout48 _619_/Q _572_/A1 VPWR VPWR VGND VGND gf180mcu_fd_sc_mcu7t5v0__buf_4
Xfanout37 _329_/Z _505_/A1 VPWR VPWR VGND VGND gf180mcu_fd_sc_mcu7t5v0__buf_2
XTAP_TAPCELL_ROW_1_104 VPWR VGND gf180mcu_fd_sc_mcu7t5v0__filltie
X_442_ _430_/I _442_/A2 _454_/A2 VPWR VPWR VGND VGND gf180mcu_fd_sc_mcu7t5v0__nand2_2
X_373_ _364_/B _332_/Z _527_/A2 _376_/A2 VPWR VPWR VGND VGND gf180mcu_fd_sc_mcu7t5v0__nor3_1
XPHY_EDGE_ROW_35_Left_84 VPWR VGND gf180mcu_fd_sc_mcu7t5v0__endcap
X_511_ _518_/A2 _511_/A2 _511_/A3 _511_/A4 _511_/Z VPWR VPWR VGND VGND gf180mcu_fd_sc_mcu7t5v0__and4_2
XFILLER_40_34 VPWR VPWR VGND VGND gf180mcu_fd_sc_mcu7t5v0__fill_1
XFILLER_39_163 VPWR VPWR VGND VGND gf180mcu_fd_sc_mcu7t5v0__fillcap_16
X_356_ _346_/B _515_/A2 _485_/B2 _338_/Z _483_/B VPWR VPWR VGND VGND gf180mcu_fd_sc_mcu7t5v0__nand4_4
X_425_ _496_/B2 _425_/A2 _425_/A3 _486_/B _426_/A2 VPWR VPWR VGND VGND gf180mcu_fd_sc_mcu7t5v0__oai31_4
XFILLER_42_103 VPWR VPWR VGND VGND gf180mcu_fd_sc_mcu7t5v0__fill_2
XFILLER_36_177 VPWR VPWR VGND VGND gf180mcu_fd_sc_mcu7t5v0__fillcap_4
XFILLER_10_37 VPWR VPWR VGND VGND gf180mcu_fd_sc_mcu7t5v0__fill_1
XFILLER_42_158 VPWR VPWR VGND VGND gf180mcu_fd_sc_mcu7t5v0__fillcap_16
XTAP_TAPCELL_ROW_37_194 VPWR VGND gf180mcu_fd_sc_mcu7t5v0__filltie
XFILLER_33_136 VPWR VPWR VGND VGND gf180mcu_fd_sc_mcu7t5v0__fillcap_4
XFILLER_33_147 VPWR VPWR VGND VGND gf180mcu_fd_sc_mcu7t5v0__fill_1
XTAP_TAPCELL_ROW_28_172 VPWR VGND gf180mcu_fd_sc_mcu7t5v0__filltie
X_408_ _475_/A2 _493_/A2 _499_/B _386_/B _439_/A2 VPWR VPWR VGND VGND gf180mcu_fd_sc_mcu7t5v0__nand4_4
XFILLER_18_177 VPWR VPWR VGND VGND gf180mcu_fd_sc_mcu7t5v0__fillcap_4
XFILLER_44_2 VPWR VPWR VGND VGND gf180mcu_fd_sc_mcu7t5v0__fill_2
XTAP_TAPCELL_ROW_34_186 VPWR VGND gf180mcu_fd_sc_mcu7t5v0__filltie
XPHY_EDGE_ROW_22_Left_71 VPWR VGND gf180mcu_fd_sc_mcu7t5v0__endcap
X_339_ _566_/A1 _346_/A1 _336_/Z _394_/A3 VPWR VPWR VGND VGND gf180mcu_fd_sc_mcu7t5v0__nor3_2
XTAP_TAPCELL_ROW_25_164 VPWR VGND gf180mcu_fd_sc_mcu7t5v0__filltie
XFILLER_21_14 VPWR VPWR VGND VGND gf180mcu_fd_sc_mcu7t5v0__fill_1
XTAP_TAPCELL_ROW_48_223 VPWR VGND gf180mcu_fd_sc_mcu7t5v0__filltie
XTAP_TAPCELL_ROW_31_178 VPWR VGND gf180mcu_fd_sc_mcu7t5v0__filltie
XFILLER_21_139 VPWR VPWR VGND VGND gf180mcu_fd_sc_mcu7t5v0__fill_1
XFILLER_11_80 VPWR VPWR VGND VGND gf180mcu_fd_sc_mcu7t5v0__fillcap_4
XTAP_TAPCELL_ROW_16_142 VPWR VGND gf180mcu_fd_sc_mcu7t5v0__filltie
XTAP_TAPCELL_ROW_22_156 VPWR VGND gf180mcu_fd_sc_mcu7t5v0__filltie
XTAP_TAPCELL_ROW_13_134 VPWR VGND gf180mcu_fd_sc_mcu7t5v0__filltie
XFILLER_43_23 VPWR VPWR VGND VGND gf180mcu_fd_sc_mcu7t5v0__fill_2
XTAP_TAPCELL_ROW_42_207 VPWR VGND gf180mcu_fd_sc_mcu7t5v0__filltie
X_587_ _577_/Z _587_/A2 _587_/Z VPWR VPWR VGND VGND gf180mcu_fd_sc_mcu7t5v0__xor2_1
XTAP_TAPCELL_ROW_10_126 VPWR VGND gf180mcu_fd_sc_mcu7t5v0__filltie
Xfanout38 _329_/Z _364_/B VPWR VPWR VGND VGND gf180mcu_fd_sc_mcu7t5v0__buf_1
Xfanout49 _618_/Q _346_/B VPWR VPWR VGND VGND gf180mcu_fd_sc_mcu7t5v0__buf_3
X_441_ _450_/A1 _447_/A2 _391_/Z _442_/A2 VPWR VPWR VGND VGND gf180mcu_fd_sc_mcu7t5v0__nor3_4
X_510_ _474_/B _510_/A2 _510_/B _510_/C _511_/A4 VPWR VPWR VGND VGND gf180mcu_fd_sc_mcu7t5v0__aoi211_1
X_372_ _388_/B _495_/A2 _485_/C VPWR VPWR VGND VGND gf180mcu_fd_sc_mcu7t5v0__nand2_2
XFILLER_39_142 VPWR VPWR VGND VGND gf180mcu_fd_sc_mcu7t5v0__fillcap_4
X_355_ _369_/B _369_/A1 _514_/B VPWR VPWR VGND VGND gf180mcu_fd_sc_mcu7t5v0__nor2_1
X_424_ wire42/I _444_/B _446_/A2 VPWR VPWR VGND VGND gf180mcu_fd_sc_mcu7t5v0__nand2_1
XFILLER_19_69 VPWR VPWR VGND VGND gf180mcu_fd_sc_mcu7t5v0__fill_1
XPHY_EDGE_ROW_23_Right_23 VPWR VGND gf180mcu_fd_sc_mcu7t5v0__endcap
XFILLER_4_2 VPWR VPWR VGND VGND gf180mcu_fd_sc_mcu7t5v0__fillcap_32
XPHY_EDGE_ROW_14_Right_14 VPWR VGND gf180mcu_fd_sc_mcu7t5v0__endcap
X_407_ _530_/B _478_/B _428_/A1 VPWR VPWR VGND VGND gf180mcu_fd_sc_mcu7t5v0__nand2_1
XPHY_EDGE_ROW_41_Right_41 VPWR VGND gf180mcu_fd_sc_mcu7t5v0__endcap
XFILLER_41_181 VPWR VPWR VGND VGND gf180mcu_fd_sc_mcu7t5v0__fill_1
XPHY_EDGE_ROW_32_Right_32 VPWR VGND gf180mcu_fd_sc_mcu7t5v0__endcap
X_338_ _346_/A1 _336_/Z _338_/Z VPWR VPWR VGND VGND gf180mcu_fd_sc_mcu7t5v0__or2_4
XTAP_TAPCELL_ROW_34_187 VPWR VGND gf180mcu_fd_sc_mcu7t5v0__filltie
XFILLER_32_181 VPWR VPWR VGND VGND gf180mcu_fd_sc_mcu7t5v0__fill_1
XFILLER_30_107 VPWR VPWR VGND VGND gf180mcu_fd_sc_mcu7t5v0__fill_2
XFILLER_23_181 VPWR VPWR VGND VGND gf180mcu_fd_sc_mcu7t5v0__fill_1
XTAP_TAPCELL_ROW_48_224 VPWR VGND gf180mcu_fd_sc_mcu7t5v0__filltie
XTAP_TAPCELL_ROW_31_179 VPWR VGND gf180mcu_fd_sc_mcu7t5v0__filltie
XFILLER_14_181 VPWR VPWR VGND VGND gf180mcu_fd_sc_mcu7t5v0__fill_1
XFILLER_32_58 VPWR VPWR VGND VGND gf180mcu_fd_sc_mcu7t5v0__fill_2
XTAP_TAPCELL_ROW_22_157 VPWR VGND gf180mcu_fd_sc_mcu7t5v0__filltie
XFILLER_16_37 VPWR VPWR VGND VGND gf180mcu_fd_sc_mcu7t5v0__fillcap_4
XFILLER_16_59 VPWR VPWR VGND VGND gf180mcu_fd_sc_mcu7t5v0__fill_1
XFILLER_20_151 VPWR VPWR VGND VGND gf180mcu_fd_sc_mcu7t5v0__fill_1
XPHY_EDGE_ROW_4_Right_4 VPWR VGND gf180mcu_fd_sc_mcu7t5v0__endcap
XFILLER_43_35 VPWR VPWR VGND VGND gf180mcu_fd_sc_mcu7t5v0__fill_2
XTAP_TAPCELL_ROW_10_127 VPWR VGND gf180mcu_fd_sc_mcu7t5v0__filltie
X_586_ _584_/Z _593_/A2 _587_/A2 VPWR VPWR VGND VGND gf180mcu_fd_sc_mcu7t5v0__nand2_1
Xfanout17 _534_/A1 _538_/B VPWR VPWR VGND VGND gf180mcu_fd_sc_mcu7t5v0__buf_4
Xfanout39 _545_/ZN _561_/B VPWR VPWR VGND VGND gf180mcu_fd_sc_mcu7t5v0__dlyb_1
X_440_ _440_/A1 _539_/B _440_/A3 _440_/A4 _450_/A1 VPWR VPWR VGND VGND gf180mcu_fd_sc_mcu7t5v0__nand4_2
X_371_ _485_/B2 _515_/C _461_/A2 VPWR VPWR VGND VGND gf180mcu_fd_sc_mcu7t5v0__nor2_1
X_569_ _569_/A1 _569_/A2 _569_/B _576_/A2 VPWR VPWR VGND VGND gf180mcu_fd_sc_mcu7t5v0__aoi21_1
XFILLER_0_172 VPWR VPWR VGND VGND gf180mcu_fd_sc_mcu7t5v0__fillcap_8
XFILLER_39_110 VPWR VPWR VGND VGND gf180mcu_fd_sc_mcu7t5v0__fill_1
XFILLER_24_37 VPWR VPWR VGND VGND gf180mcu_fd_sc_mcu7t5v0__fillcap_16
XFILLER_5_72 VPWR VPWR VGND VGND gf180mcu_fd_sc_mcu7t5v0__fillcap_64
X_354_ _541_/A1 _501_/A2 _369_/A1 VPWR VPWR VGND VGND gf180mcu_fd_sc_mcu7t5v0__nor2_1
X_423_ _566_/A1 _533_/C _425_/A3 VPWR VPWR VGND VGND gf180mcu_fd_sc_mcu7t5v0__nor2_1
XFILLER_44_4 VPWR VPWR VGND VGND gf180mcu_fd_sc_mcu7t5v0__fill_1
X_406_ wire42/Z _478_/B _444_/A2 _538_/B _517_/A1 VPWR VPWR VGND VGND gf180mcu_fd_sc_mcu7t5v0__aoi22_4
X_337_ _346_/A1 _336_/Z _386_/A1 VPWR VPWR VGND VGND gf180mcu_fd_sc_mcu7t5v0__nor2_4
XFILLER_18_124 VPWR VPWR VGND VGND gf180mcu_fd_sc_mcu7t5v0__fillcap_4
XFILLER_15_138 VPWR VPWR VGND VGND gf180mcu_fd_sc_mcu7t5v0__fill_2
XFILLER_16_49 VPWR VPWR VGND VGND gf180mcu_fd_sc_mcu7t5v0__fill_1
XFILLER_11_174 VPWR VPWR VGND VGND gf180mcu_fd_sc_mcu7t5v0__fillcap_8
XFILLER_43_69 VPWR VPWR VGND VGND gf180mcu_fd_sc_mcu7t5v0__fill_1
X_585_ _598_/A3 _585_/A2 _585_/B _593_/A2 VPWR VPWR VGND VGND gf180mcu_fd_sc_mcu7t5v0__oai21_1
XFILLER_12_2 VPWR VPWR VGND VGND gf180mcu_fd_sc_mcu7t5v0__fillcap_16
X_370_ _391_/A4 _534_/B _542_/A1 VPWR VPWR VGND VGND gf180mcu_fd_sc_mcu7t5v0__nor2_1
X_499_ _388_/B _340_/Z _499_/B _533_/B _507_/A2 VPWR VPWR VGND VGND gf180mcu_fd_sc_mcu7t5v0__oai211_1
X_568_ _568_/A1 _616_/Q _617_/Q _569_/B VPWR VPWR VGND VGND gf180mcu_fd_sc_mcu7t5v0__nand3_1
XPHY_EDGE_ROW_39_Left_88 VPWR VGND gf180mcu_fd_sc_mcu7t5v0__endcap
X_353_ _505_/A1 _485_/B2 _340_/Z _515_/B _501_/A2 VPWR VPWR VGND VGND gf180mcu_fd_sc_mcu7t5v0__oai31_4
X_422_ _425_/A2 _486_/B _517_/A2 VPWR VPWR VGND VGND gf180mcu_fd_sc_mcu7t5v0__nand2_1
XFILLER_27_103 VPWR VPWR VGND VGND gf180mcu_fd_sc_mcu7t5v0__fill_1
XFILLER_19_38 VPWR VPWR VGND VGND gf180mcu_fd_sc_mcu7t5v0__fill_2
X_336_ _328_/B _335_/B _346_/B _336_/Z VPWR VPWR VGND VGND gf180mcu_fd_sc_mcu7t5v0__and3_2
XFILLER_18_147 VPWR VPWR VGND VGND gf180mcu_fd_sc_mcu7t5v0__fillcap_16
X_405_ _527_/B1 _505_/C _444_/A2 VPWR VPWR VGND VGND gf180mcu_fd_sc_mcu7t5v0__nand2_2
X_319_ _319_/A1 _622_/Q _319_/A3 _323_/B1 VPWR VPWR VGND VGND gf180mcu_fd_sc_mcu7t5v0__nor3_4
XFILLER_42_2 VPWR VPWR VGND VGND gf180mcu_fd_sc_mcu7t5v0__fill_1
Xclkbuf_1_0__f_clk clkbuf_0_clk/Z _620_/CLK VPWR VPWR VGND VGND gf180mcu_fd_sc_mcu7t5v0__clkbuf_16
XPHY_EDGE_ROW_26_Left_75 VPWR VGND gf180mcu_fd_sc_mcu7t5v0__endcap
XPHY_EDGE_ROW_10_Left_59 VPWR VGND gf180mcu_fd_sc_mcu7t5v0__endcap
XFILLER_14_150 VPWR VPWR VGND VGND gf180mcu_fd_sc_mcu7t5v0__fillcap_16
XFILLER_11_142 VPWR VPWR VGND VGND gf180mcu_fd_sc_mcu7t5v0__fillcap_32
X_584_ _585_/B _598_/A3 _585_/A2 _584_/Z VPWR VPWR VGND VGND gf180mcu_fd_sc_mcu7t5v0__or3_1
XFILLER_13_18 VPWR VPWR VGND VGND gf180mcu_fd_sc_mcu7t5v0__fill_1
XFILLER_48_134 VPWR VPWR VGND VGND gf180mcu_fd_sc_mcu7t5v0__fill_2
XFILLER_38_37 VPWR VPWR VGND VGND gf180mcu_fd_sc_mcu7t5v0__fill_2
XPHY_EDGE_ROW_13_Left_62 VPWR VGND gf180mcu_fd_sc_mcu7t5v0__endcap
XFILLER_44_80 VPWR VPWR VGND VGND gf180mcu_fd_sc_mcu7t5v0__fillcap_4
X_498_ _340_/Z _498_/A2 _498_/A3 _508_/B1 VPWR VPWR VGND VGND gf180mcu_fd_sc_mcu7t5v0__nand3_1
X_567_ _568_/A1 _616_/Q _617_/Q _570_/B VPWR VPWR VGND VGND gf180mcu_fd_sc_mcu7t5v0__and3_1
X_421_ _395_/Z _420_/Z _526_/B2 VPWR VPWR VGND VGND gf180mcu_fd_sc_mcu7t5v0__nor2_1
XFILLER_44_181 VPWR VPWR VGND VGND gf180mcu_fd_sc_mcu7t5v0__fill_1
X_352_ _340_/Z _533_/A2 _504_/B1 VPWR VPWR VGND VGND gf180mcu_fd_sc_mcu7t5v0__nor2_4
XFILLER_30_93 VPWR VPWR VGND VGND gf180mcu_fd_sc_mcu7t5v0__fillcap_4
X_619_ _619_/D _626_/RN _620_/CLK _619_/Q VPWR VPWR VGND VGND gf180mcu_fd_sc_mcu7t5v0__dffrnq_2
XPHY_EDGE_ROW_40_Left_89 VPWR VGND gf180mcu_fd_sc_mcu7t5v0__endcap
XFILLER_26_181 VPWR VPWR VGND VGND gf180mcu_fd_sc_mcu7t5v0__fill_1
X_335_ _328_/B _346_/B _335_/B _346_/A1 VPWR VPWR VGND VGND gf180mcu_fd_sc_mcu7t5v0__aoi21_4
X_404_ _505_/A1 _332_/Z _480_/A2 _505_/C VPWR VPWR VGND VGND gf180mcu_fd_sc_mcu7t5v0__nand3_2
XPHY_EDGE_ROW_10_Right_10 VPWR VGND gf180mcu_fd_sc_mcu7t5v0__endcap
XFILLER_17_170 VPWR VPWR VGND VGND gf180mcu_fd_sc_mcu7t5v0__fill_1
XFILLER_17_181 VPWR VPWR VGND VGND gf180mcu_fd_sc_mcu7t5v0__fill_1
XFILLER_2_2 VPWR VPWR VGND VGND gf180mcu_fd_sc_mcu7t5v0__fillcap_32
XFILLER_15_118 VPWR VPWR VGND VGND gf180mcu_fd_sc_mcu7t5v0__fillcap_16
X_318_ _599_/A1 _392_/A1 _323_/C _420_/A2 VPWR VPWR VGND VGND gf180mcu_fd_sc_mcu7t5v0__oai21_4
XPHY_EDGE_ROW_1_Left_50 VPWR VGND gf180mcu_fd_sc_mcu7t5v0__endcap
XPHY_EDGE_ROW_43_Left_92 VPWR VGND gf180mcu_fd_sc_mcu7t5v0__endcap
XFILLER_7_136 VPWR VPWR VGND VGND gf180mcu_fd_sc_mcu7t5v0__fillcap_4
XFILLER_21_8 VPWR VPWR VGND VGND gf180mcu_fd_sc_mcu7t5v0__fill_1
X_583_ _585_/B _598_/A3 _585_/A2 _593_/B VPWR VPWR VGND VGND gf180mcu_fd_sc_mcu7t5v0__nor3_1
XPHY_EDGE_ROW_8_Right_8 VPWR VGND gf180mcu_fd_sc_mcu7t5v0__endcap
XPHY_EDGE_ROW_48_Right_48 VPWR VGND gf180mcu_fd_sc_mcu7t5v0__endcap
XPHY_EDGE_ROW_39_Right_39 VPWR VGND gf180mcu_fd_sc_mcu7t5v0__endcap
X_497_ _310_/Z _503_/B _497_/B _528_/B VPWR VPWR VGND VGND gf180mcu_fd_sc_mcu7t5v0__oai21_2
X_566_ _566_/A1 _566_/A2 _618_/D VPWR VPWR VGND VGND gf180mcu_fd_sc_mcu7t5v0__xor2_1
XFILLER_39_179 VPWR VPWR VGND VGND gf180mcu_fd_sc_mcu7t5v0__fill_2
XFILLER_39_146 VPWR VPWR VGND VGND gf180mcu_fd_sc_mcu7t5v0__fill_1
X_420_ _314_/Z _420_/A2 _321_/Z _420_/Z VPWR VPWR VGND VGND gf180mcu_fd_sc_mcu7t5v0__or3_1
X_351_ _351_/A1 _515_/A2 _533_/A2 VPWR VPWR VGND VGND gf180mcu_fd_sc_mcu7t5v0__nand2_4
X_549_ _611_/Q _549_/A2 _611_/D VPWR VPWR VGND VGND gf180mcu_fd_sc_mcu7t5v0__xnor2_1
XFILLER_19_18 VPWR VPWR VGND VGND gf180mcu_fd_sc_mcu7t5v0__fillcap_8
X_618_ _618_/D _626_/RN _620_/CLK _618_/Q VPWR VPWR VGND VGND gf180mcu_fd_sc_mcu7t5v0__dffrnq_2
XFILLER_41_163 VPWR VPWR VGND VGND gf180mcu_fd_sc_mcu7t5v0__fillcap_16
XFILLER_25_72 VPWR VPWR VGND VGND gf180mcu_fd_sc_mcu7t5v0__fill_1
X_403_ _346_/B _498_/A3 _486_/A1 VPWR VPWR VGND VGND gf180mcu_fd_sc_mcu7t5v0__nor2_1
X_334_ _515_/A2 _485_/B2 _533_/C VPWR VPWR VGND VGND gf180mcu_fd_sc_mcu7t5v0__nand2_4
X_317_ _328_/B _599_/A1 _323_/C VPWR VPWR VGND VGND gf180mcu_fd_sc_mcu7t5v0__nand2_1
XFILLER_14_174 VPWR VPWR VGND VGND gf180mcu_fd_sc_mcu7t5v0__fill_1
XFILLER_28_2 VPWR VPWR VGND VGND gf180mcu_fd_sc_mcu7t5v0__fill_2
XFILLER_20_177 VPWR VPWR VGND VGND gf180mcu_fd_sc_mcu7t5v0__fillcap_4
XFILLER_6_181 VPWR VPWR VGND VGND gf180mcu_fd_sc_mcu7t5v0__fill_1
X_582_ _621_/Q _622_/Q _589_/A2 _585_/A2 VPWR VPWR VGND VGND gf180mcu_fd_sc_mcu7t5v0__nor3_1
XFILLER_4_107 VPWR VPWR VGND VGND gf180mcu_fd_sc_mcu7t5v0__fillcap_64
XFILLER_17_62 VPWR VPWR VGND VGND gf180mcu_fd_sc_mcu7t5v0__fill_1
XFILLER_38_28 VPWR VPWR VGND VGND gf180mcu_fd_sc_mcu7t5v0__fill_1
X_496_ _496_/A1 _538_/B _496_/B1 _496_/B2 _529_/B _518_/A2 VPWR VPWR VGND VGND gf180mcu_fd_sc_mcu7t5v0__aoi221_4
X_565_ _617_/Q _562_/Z _617_/D VPWR VPWR VGND VGND gf180mcu_fd_sc_mcu7t5v0__xor2_1
XFILLER_10_2 VPWR VPWR VGND VGND gf180mcu_fd_sc_mcu7t5v0__fillcap_32
X_350_ _575_/B _621_/Q _378_/A2 _515_/B VPWR VPWR VGND VGND gf180mcu_fd_sc_mcu7t5v0__nand3_2
X_548_ _610_/Q _611_/Q _548_/Z VPWR VPWR VGND VGND gf180mcu_fd_sc_mcu7t5v0__and2_1
XFILLER_29_180 VPWR VPWR VGND VGND gf180mcu_fd_sc_mcu7t5v0__fill_2
X_479_ _535_/A2 _479_/A2 _479_/A3 _479_/A4 _488_/A1 VPWR VPWR VGND VGND gf180mcu_fd_sc_mcu7t5v0__nand4_2
X_617_ _617_/D _626_/RN _620_/CLK _617_/Q VPWR VPWR VGND VGND gf180mcu_fd_sc_mcu7t5v0__dffrnq_1
X_402_ _464_/A2 _504_/B2 _506_/A2 VPWR VPWR VGND VGND gf180mcu_fd_sc_mcu7t5v0__nand2_1
X_333_ _333_/A1 _621_/Q _333_/Z VPWR VPWR VGND VGND gf180mcu_fd_sc_mcu7t5v0__xor2_1
XFILLER_25_40 VPWR VPWR VGND VGND gf180mcu_fd_sc_mcu7t5v0__fillcap_4
X_316_ _316_/A1 _319_/A1 _316_/B _316_/C _392_/A1 VPWR VPWR VGND VGND gf180mcu_fd_sc_mcu7t5v0__oai211_4
XFILLER_11_134 VPWR VPWR VGND VGND gf180mcu_fd_sc_mcu7t5v0__fillcap_4
XTAP_TAPCELL_ROW_44_210 VPWR VGND gf180mcu_fd_sc_mcu7t5v0__filltie
XFILLER_6_171 VPWR VPWR VGND VGND gf180mcu_fd_sc_mcu7t5v0__fillcap_4
X_581_ _581_/A1 _581_/A2 _581_/B _598_/A3 VPWR VPWR VGND VGND gf180mcu_fd_sc_mcu7t5v0__aoi21_2
XFILLER_3_174 VPWR VPWR VGND VGND gf180mcu_fd_sc_mcu7t5v0__fillcap_8
XTAP_TAPCELL_ROW_0_100 VPWR VGND gf180mcu_fd_sc_mcu7t5v0__filltie
XFILLER_48_104 VPWR VPWR VGND VGND gf180mcu_fd_sc_mcu7t5v0__fill_2
X_495_ _504_/B1 _495_/A2 _494_/Z _538_/B _512_/A1 VPWR VPWR VGND VGND gf180mcu_fd_sc_mcu7t5v0__oai31_2
X_564_ _617_/Q _562_/Z _566_/A2 VPWR VPWR VGND VGND gf180mcu_fd_sc_mcu7t5v0__nand2_1
XFILLER_5_66 VPWR VPWR VGND VGND gf180mcu_fd_sc_mcu7t5v0__fillcap_4
XPHY_EDGE_ROW_17_Left_66 VPWR VGND gf180mcu_fd_sc_mcu7t5v0__endcap
XFILLER_38_181 VPWR VPWR VGND VGND gf180mcu_fd_sc_mcu7t5v0__fill_1
X_547_ _610_/Q _561_/B _610_/D VPWR VPWR VGND VGND gf180mcu_fd_sc_mcu7t5v0__xnor2_1
XFILLER_36_107 VPWR VPWR VGND VGND gf180mcu_fd_sc_mcu7t5v0__fill_2
X_478_ _541_/A3 _365_/Z _478_/B _535_/A2 VPWR VPWR VGND VGND gf180mcu_fd_sc_mcu7t5v0__oai21_2
X_616_ _616_/D _626_/RN _620_/CLK _616_/Q VPWR VPWR VGND VGND gf180mcu_fd_sc_mcu7t5v0__dffrnq_1
XTAP_TAPCELL_ROW_36_190 VPWR VGND gf180mcu_fd_sc_mcu7t5v0__filltie
X_332_ _581_/A1 _333_/A1 _332_/Z VPWR VPWR VGND VGND gf180mcu_fd_sc_mcu7t5v0__xor2_2
X_401_ _314_/Z _321_/Z _392_/Z _401_/ZN VPWR VPWR VGND VGND gf180mcu_fd_sc_mcu7t5v0__nor3_1
XFILLER_2_34 VPWR VPWR VGND VGND gf180mcu_fd_sc_mcu7t5v0__fill_1
XFILLER_17_162 VPWR VPWR VGND VGND gf180mcu_fd_sc_mcu7t5v0__fill_2
XFILLER_36_62 VPWR VPWR VGND VGND gf180mcu_fd_sc_mcu7t5v0__fill_2
X_315_ _328_/B _623_/Q _316_/C VPWR VPWR VGND VGND gf180mcu_fd_sc_mcu7t5v0__nand2_1
XFILLER_28_4 VPWR VPWR VGND VGND gf180mcu_fd_sc_mcu7t5v0__fill_1
XTAP_TAPCELL_ROW_24_160 VPWR VGND gf180mcu_fd_sc_mcu7t5v0__filltie
XFILLER_11_102 VPWR VPWR VGND VGND gf180mcu_fd_sc_mcu7t5v0__fillcap_32
XTAP_TAPCELL_ROW_44_211 VPWR VGND gf180mcu_fd_sc_mcu7t5v0__filltie
XPHY_EDGE_ROW_5_Left_54 VPWR VGND gf180mcu_fd_sc_mcu7t5v0__endcap
XFILLER_0_2 VPWR VPWR VGND VGND gf180mcu_fd_sc_mcu7t5v0__fillcap_32
XTAP_TAPCELL_ROW_12_130 VPWR VGND gf180mcu_fd_sc_mcu7t5v0__filltie
XPHY_EDGE_ROW_47_Left_96 VPWR VGND gf180mcu_fd_sc_mcu7t5v0__endcap
XFILLER_33_2 VPWR VPWR VGND VGND gf180mcu_fd_sc_mcu7t5v0__fill_2
XTAP_TAPCELL_ROW_41_203 VPWR VGND gf180mcu_fd_sc_mcu7t5v0__filltie
X_580_ _622_/Q _561_/B _588_/B VPWR VPWR VGND VGND gf180mcu_fd_sc_mcu7t5v0__nand2_1
XFILLER_3_142 VPWR VPWR VGND VGND gf180mcu_fd_sc_mcu7t5v0__fillcap_32
XTAP_TAPCELL_ROW_0_101 VPWR VGND gf180mcu_fd_sc_mcu7t5v0__filltie
XPHY_EDGE_ROW_26_Right_26 VPWR VGND gf180mcu_fd_sc_mcu7t5v0__endcap
X_563_ _616_/Q _563_/A2 _616_/D VPWR VPWR VGND VGND gf180mcu_fd_sc_mcu7t5v0__xor2_1
XPHY_EDGE_ROW_17_Right_17 VPWR VGND gf180mcu_fd_sc_mcu7t5v0__endcap
XPHY_EDGE_ROW_44_Right_44 VPWR VGND gf180mcu_fd_sc_mcu7t5v0__endcap
XPHY_EDGE_ROW_35_Right_35 VPWR VGND gf180mcu_fd_sc_mcu7t5v0__endcap
X_494_ _541_/A1 _501_/A3 _494_/Z VPWR VPWR VGND VGND gf180mcu_fd_sc_mcu7t5v0__or2_1
X_546_ _610_/Q _626_/D _626_/Q _549_/A2 VPWR VPWR VGND VGND gf180mcu_fd_sc_mcu7t5v0__nand3_1
XPHY_EDGE_ROW_34_Left_83 VPWR VGND gf180mcu_fd_sc_mcu7t5v0__endcap
X_615_ _615_/D _626_/RN _620_/CLK _615_/Q VPWR VPWR VGND VGND gf180mcu_fd_sc_mcu7t5v0__dffrnq_1
X_477_ _477_/I _541_/A3 VPWR VPWR VGND VGND gf180mcu_fd_sc_mcu7t5v0__inv_2
X_400_ _314_/Z _392_/Z _504_/B2 VPWR VPWR VGND VGND gf180mcu_fd_sc_mcu7t5v0__nor2_2
XTAP_TAPCELL_ROW_36_191 VPWR VGND gf180mcu_fd_sc_mcu7t5v0__filltie
X_331_ _568_/A1 _572_/A1 _620_/Q _331_/B _333_/A1 VPWR VPWR VGND VGND gf180mcu_fd_sc_mcu7t5v0__oai31_4
XFILLER_26_174 VPWR VPWR VGND VGND gf180mcu_fd_sc_mcu7t5v0__fill_1
X_529_ _444_/B _538_/A3 _529_/B _537_/A2 VPWR VPWR VGND VGND gf180mcu_fd_sc_mcu7t5v0__aoi21_1
XFILLER_32_177 VPWR VPWR VGND VGND gf180mcu_fd_sc_mcu7t5v0__fillcap_4
XFILLER_32_111 VPWR VPWR VGND VGND gf180mcu_fd_sc_mcu7t5v0__fill_2
XTAP_TAPCELL_ROW_33_183 VPWR VGND gf180mcu_fd_sc_mcu7t5v0__filltie
X_314_ _623_/Q _314_/A2 _314_/Z VPWR VPWR VGND VGND gf180mcu_fd_sc_mcu7t5v0__xor2_2
XTAP_TAPCELL_ROW_24_161 VPWR VGND gf180mcu_fd_sc_mcu7t5v0__filltie
XFILLER_14_166 VPWR VPWR VGND VGND gf180mcu_fd_sc_mcu7t5v0__fillcap_8
XFILLER_14_177 VPWR VPWR VGND VGND gf180mcu_fd_sc_mcu7t5v0__fillcap_4
XTAP_TAPCELL_ROW_30_175 VPWR VGND gf180mcu_fd_sc_mcu7t5v0__filltie
XTAP_TAPCELL_ROW_7_118 VPWR VGND gf180mcu_fd_sc_mcu7t5v0__filltie
XPHY_EDGE_ROW_21_Left_70 VPWR VGND gf180mcu_fd_sc_mcu7t5v0__endcap
XTAP_TAPCELL_ROW_44_212 VPWR VGND gf180mcu_fd_sc_mcu7t5v0__filltie
XTAP_TAPCELL_ROW_21_153 VPWR VGND gf180mcu_fd_sc_mcu7t5v0__filltie
XFILLER_8_34 VPWR VPWR VGND VGND gf180mcu_fd_sc_mcu7t5v0__fill_1
XTAP_TAPCELL_ROW_12_131 VPWR VGND gf180mcu_fd_sc_mcu7t5v0__filltie
XFILLER_26_2 VPWR VPWR VGND VGND gf180mcu_fd_sc_mcu7t5v0__fill_1
XTAP_TAPCELL_ROW_41_204 VPWR VGND gf180mcu_fd_sc_mcu7t5v0__filltie
XTAP_TAPCELL_ROW_0_102 VPWR VGND gf180mcu_fd_sc_mcu7t5v0__filltie
XFILLER_39_139 VPWR VPWR VGND VGND gf180mcu_fd_sc_mcu7t5v0__fill_1
X_493_ _500_/B _493_/A2 _503_/A1 _501_/A3 VPWR VPWR VGND VGND gf180mcu_fd_sc_mcu7t5v0__nand3_1
X_562_ _616_/Q _563_/A2 _562_/Z VPWR VPWR VGND VGND gf180mcu_fd_sc_mcu7t5v0__and2_1
X_545_ _626_/D _626_/Q _545_/ZN VPWR VPWR VGND VGND gf180mcu_fd_sc_mcu7t5v0__nand2_1
X_476_ _533_/A2 _476_/I1 _476_/S _477_/I VPWR VPWR VGND VGND gf180mcu_fd_sc_mcu7t5v0__mux2_2
X_614_ _614_/D _626_/RN _620_/CLK _614_/Q VPWR VPWR VGND VGND gf180mcu_fd_sc_mcu7t5v0__dffrnq_1
XFILLER_41_123 VPWR VPWR VGND VGND gf180mcu_fd_sc_mcu7t5v0__fillcap_4
XTAP_TAPCELL_ROW_36_192 VPWR VGND gf180mcu_fd_sc_mcu7t5v0__filltie
X_330_ _575_/B _330_/A2 _330_/Z VPWR VPWR VGND VGND gf180mcu_fd_sc_mcu7t5v0__xor2_4
X_528_ _528_/A1 _444_/B _528_/B _528_/C _536_/A2 VPWR VPWR VGND VGND gf180mcu_fd_sc_mcu7t5v0__aoi211_4
X_459_ _473_/A1 _459_/A2 _538_/B _490_/A4 VPWR VPWR VGND VGND gf180mcu_fd_sc_mcu7t5v0__oai21_2
XFILLER_17_142 VPWR VPWR VGND VGND gf180mcu_fd_sc_mcu7t5v0__fillcap_16
XTAP_TAPCELL_ROW_19_148 VPWR VGND gf180mcu_fd_sc_mcu7t5v0__filltie
XTAP_TAPCELL_ROW_33_184 VPWR VGND gf180mcu_fd_sc_mcu7t5v0__filltie
X_313_ _623_/Q _314_/A2 _324_/A1 VPWR VPWR VGND VGND gf180mcu_fd_sc_mcu7t5v0__xnor2_2
XFILLER_36_64 VPWR VPWR VGND VGND gf180mcu_fd_sc_mcu7t5v0__fill_1
XTAP_TAPCELL_ROW_24_162 VPWR VGND gf180mcu_fd_sc_mcu7t5v0__filltie
XTAP_TAPCELL_ROW_30_176 VPWR VGND gf180mcu_fd_sc_mcu7t5v0__filltie
XTAP_TAPCELL_ROW_7_119 VPWR VGND gf180mcu_fd_sc_mcu7t5v0__filltie
XTAP_TAPCELL_ROW_21_154 VPWR VGND gf180mcu_fd_sc_mcu7t5v0__filltie
XFILLER_10_181 VPWR VPWR VGND VGND gf180mcu_fd_sc_mcu7t5v0__fill_1
XTAP_TAPCELL_ROW_12_132 VPWR VGND gf180mcu_fd_sc_mcu7t5v0__filltie
XFILLER_19_2 VPWR VPWR VGND VGND gf180mcu_fd_sc_mcu7t5v0__fillcap_16
XPHY_EDGE_ROW_3_Right_3 VPWR VGND gf180mcu_fd_sc_mcu7t5v0__endcap
X_492_ _492_/A1 _386_/B _504_/C VPWR VPWR VGND VGND gf180mcu_fd_sc_mcu7t5v0__nor2_1
Xclkbuf_1_1__f_clk clkbuf_0_clk/Z _626_/CLK VPWR VPWR VGND VGND gf180mcu_fd_sc_mcu7t5v0__clkbuf_16
XFILLER_28_87 VPWR VPWR VGND VGND gf180mcu_fd_sc_mcu7t5v0__fillcap_4
X_561_ _569_/A1 _569_/A2 _561_/B _563_/A2 VPWR VPWR VGND VGND gf180mcu_fd_sc_mcu7t5v0__aoi21_1
XFILLER_39_53 VPWR VPWR VGND VGND gf180mcu_fd_sc_mcu7t5v0__fill_1
X_613_ _613_/D _626_/RN _620_/CLK _613_/Q VPWR VPWR VGND VGND gf180mcu_fd_sc_mcu7t5v0__dffrnq_1
X_544_ _544_/A1 _544_/A2 B[4] VPWR VPWR VGND VGND gf180mcu_fd_sc_mcu7t5v0__nand2_2
X_475_ _485_/C _475_/A2 _519_/A4 VPWR VPWR VGND VGND gf180mcu_fd_sc_mcu7t5v0__nand2_1
Xwire4 wire4/I T[6] VPWR VPWR VGND VGND gf180mcu_fd_sc_mcu7t5v0__clkbuf_8
XFILLER_41_179 VPWR VPWR VGND VGND gf180mcu_fd_sc_mcu7t5v0__fill_2
XFILLER_25_44 VPWR VPWR VGND VGND gf180mcu_fd_sc_mcu7t5v0__fill_1
X_527_ _364_/B _527_/A2 _420_/Z _527_/B1 _377_/B _528_/C VPWR VPWR VGND VGND gf180mcu_fd_sc_mcu7t5v0__oai32_4
X_389_ _369_/B _390_/B1 _529_/B VPWR VPWR VGND VGND gf180mcu_fd_sc_mcu7t5v0__nor2_1
X_458_ _310_/Z _509_/A2 _395_/Z _459_/A2 VPWR VPWR VGND VGND gf180mcu_fd_sc_mcu7t5v0__nand3_1
XFILLER_2_37 VPWR VPWR VGND VGND gf180mcu_fd_sc_mcu7t5v0__fillcap_64
XTAP_TAPCELL_ROW_19_149 VPWR VGND gf180mcu_fd_sc_mcu7t5v0__filltie
X_312_ _622_/Q _310_/Z _328_/B _314_/A2 VPWR VPWR VGND VGND gf180mcu_fd_sc_mcu7t5v0__oai21_1
XFILLER_36_32 VPWR VPWR VGND VGND gf180mcu_fd_sc_mcu7t5v0__fill_2
XTAP_TAPCELL_ROW_30_177 VPWR VGND gf180mcu_fd_sc_mcu7t5v0__filltie
XFILLER_11_138 VPWR VPWR VGND VGND gf180mcu_fd_sc_mcu7t5v0__fill_2
Xwire42 wire42/I wire42/Z VPWR VPWR VGND VGND gf180mcu_fd_sc_mcu7t5v0__buf_1
XFILLER_47_86 VPWR VPWR VGND VGND gf180mcu_fd_sc_mcu7t5v0__fill_2
XFILLER_10_171 VPWR VPWR VGND VGND gf180mcu_fd_sc_mcu7t5v0__fillcap_4
XPHY_EDGE_ROW_9_Left_58 VPWR VGND gf180mcu_fd_sc_mcu7t5v0__endcap
XFILLER_31_2 VPWR VPWR VGND VGND gf180mcu_fd_sc_mcu7t5v0__fill_1
XFILLER_0_70 VPWR VPWR VGND VGND gf180mcu_fd_sc_mcu7t5v0__fillcap_32
X_491_ _471_/B _491_/A2 _509_/B VPWR VPWR VGND VGND gf180mcu_fd_sc_mcu7t5v0__nand2_1
X_560_ _612_/Q _613_/Q _614_/Q _615_/Q _560_/Z VPWR VPWR VGND VGND gf180mcu_fd_sc_mcu7t5v0__or4_1
XFILLER_0_104 VPWR VPWR VGND VGND gf180mcu_fd_sc_mcu7t5v0__fillcap_32
XPHY_EDGE_ROW_22_Right_22 VPWR VGND gf180mcu_fd_sc_mcu7t5v0__endcap
XPHY_EDGE_ROW_13_Right_13 VPWR VGND gf180mcu_fd_sc_mcu7t5v0__endcap
XPHY_EDGE_ROW_40_Right_40 VPWR VGND gf180mcu_fd_sc_mcu7t5v0__endcap
XPHY_EDGE_ROW_31_Right_31 VPWR VGND gf180mcu_fd_sc_mcu7t5v0__endcap
XFILLER_30_45 VPWR VPWR VGND VGND gf180mcu_fd_sc_mcu7t5v0__fill_2
XFILLER_44_177 VPWR VPWR VGND VGND gf180mcu_fd_sc_mcu7t5v0__fillcap_4
X_543_ _543_/A1 _543_/A2 _543_/A3 _544_/A1 VPWR VPWR VGND VGND gf180mcu_fd_sc_mcu7t5v0__nor3_2
X_612_ _612_/D _626_/RN _620_/CLK _612_/Q VPWR VPWR VGND VGND gf180mcu_fd_sc_mcu7t5v0__dffrnq_1
X_474_ _504_/B1 _474_/A2 _474_/B _479_/A3 VPWR VPWR VGND VGND gf180mcu_fd_sc_mcu7t5v0__oai21_1
Xwire5 wire5/I T[5] VPWR VPWR VGND VGND gf180mcu_fd_sc_mcu7t5v0__clkbuf_8
X_526_ _530_/B _528_/A1 _526_/A3 _526_/B1 _526_/B2 wire8/I VPWR VPWR VGND VGND gf180mcu_fd_sc_mcu7t5v0__oai32_4
XPHY_EDGE_ROW_38_Left_87 VPWR VGND gf180mcu_fd_sc_mcu7t5v0__endcap
XFILLER_26_177 VPWR VPWR VGND VGND gf180mcu_fd_sc_mcu7t5v0__fillcap_4
XFILLER_9_2 VPWR VPWR VGND VGND gf180mcu_fd_sc_mcu7t5v0__fillcap_32
X_388_ _364_/B _340_/Z _388_/B _390_/B1 VPWR VPWR VGND VGND gf180mcu_fd_sc_mcu7t5v0__oai21_1
X_457_ _493_/A2 _386_/B _473_/A1 VPWR VPWR VGND VGND gf180mcu_fd_sc_mcu7t5v0__nand2_1
X_311_ _328_/B _622_/Q _316_/B VPWR VPWR VGND VGND gf180mcu_fd_sc_mcu7t5v0__nand2_1
XFILLER_14_103 VPWR VPWR VGND VGND gf180mcu_fd_sc_mcu7t5v0__fill_2
X_509_ _377_/B _509_/A2 _509_/B _510_/C VPWR VPWR VGND VGND gf180mcu_fd_sc_mcu7t5v0__oai21_1
XFILLER_8_37 VPWR VPWR VGND VGND gf180mcu_fd_sc_mcu7t5v0__fillcap_64
XPHY_EDGE_ROW_25_Left_74 VPWR VGND gf180mcu_fd_sc_mcu7t5v0__endcap
X_490_ _490_/A1 _490_/A2 _490_/A3 _490_/A4 B[0] VPWR VPWR VGND VGND gf180mcu_fd_sc_mcu7t5v0__nand4_4
XFILLER_0_138 VPWR VPWR VGND VGND gf180mcu_fd_sc_mcu7t5v0__fillcap_32
XFILLER_47_142 VPWR VPWR VGND VGND gf180mcu_fd_sc_mcu7t5v0__fill_2
XPHY_EDGE_ROW_12_Left_61 VPWR VGND gf180mcu_fd_sc_mcu7t5v0__endcap
XFILLER_39_88 VPWR VPWR VGND VGND gf180mcu_fd_sc_mcu7t5v0__fillcap_4
X_611_ _611_/D _625_/RN _626_/CLK _611_/Q VPWR VPWR VGND VGND gf180mcu_fd_sc_mcu7t5v0__dffrnq_1
X_542_ _542_/A1 _542_/A2 _542_/A3 _542_/A4 _543_/A2 VPWR VPWR VGND VGND gf180mcu_fd_sc_mcu7t5v0__nand4_1
X_473_ _473_/A1 _473_/A2 _501_/B _479_/A2 VPWR VPWR VGND VGND gf180mcu_fd_sc_mcu7t5v0__oai21_1
Xrebuffer53 _328_/A1 _335_/B VPWR VPWR VGND VGND gf180mcu_fd_sc_mcu7t5v0__buf_8
X_456_ _456_/A1 _456_/A2 _456_/A3 wire4/I VPWR VPWR VGND VGND gf180mcu_fd_sc_mcu7t5v0__nor3_4
XFILLER_40_181 VPWR VPWR VGND VGND gf180mcu_fd_sc_mcu7t5v0__fill_1
X_387_ _493_/A2 _386_/B _499_/B _387_/Z VPWR VPWR VGND VGND gf180mcu_fd_sc_mcu7t5v0__and3_4
X_525_ _525_/A1 _525_/A2 _525_/A3 _525_/A4 B[2] VPWR VPWR VGND VGND gf180mcu_fd_sc_mcu7t5v0__or4_4
XFILLER_36_34 VPWR VPWR VGND VGND gf180mcu_fd_sc_mcu7t5v0__fill_1
X_310_ _572_/A1 _568_/A1 _620_/Q _621_/Q _310_/Z VPWR VPWR VGND VGND gf180mcu_fd_sc_mcu7t5v0__or4_2
XFILLER_11_26 VPWR VPWR VGND VGND gf180mcu_fd_sc_mcu7t5v0__fill_2
X_439_ _538_/B _439_/A2 _507_/A1 _444_/A2 _440_/A4 VPWR VPWR VGND VGND gf180mcu_fd_sc_mcu7t5v0__aoi22_4
X_508_ _508_/A1 _519_/A4 _508_/B1 _444_/B _508_/C1 _478_/B _511_/A3 VPWR VPWR VGND
+ VGND gf180mcu_fd_sc_mcu7t5v0__aoi222_2
XFILLER_22_181 VPWR VPWR VGND VGND gf180mcu_fd_sc_mcu7t5v0__fill_1
XFILLER_20_107 VPWR VPWR VGND VGND gf180mcu_fd_sc_mcu7t5v0__fill_2
XFILLER_9_174 VPWR VPWR VGND VGND gf180mcu_fd_sc_mcu7t5v0__fillcap_8
XFILLER_6_177 VPWR VPWR VGND VGND gf180mcu_fd_sc_mcu7t5v0__fillcap_4
XPHY_EDGE_ROW_42_Left_91 VPWR VGND gf180mcu_fd_sc_mcu7t5v0__endcap
XFILLER_3_136 VPWR VPWR VGND VGND gf180mcu_fd_sc_mcu7t5v0__fillcap_4
XFILLER_17_2 VPWR VPWR VGND VGND gf180mcu_fd_sc_mcu7t5v0__fillcap_16
XFILLER_44_34 VPWR VPWR VGND VGND gf180mcu_fd_sc_mcu7t5v0__fill_1
XFILLER_38_132 VPWR VPWR VGND VGND gf180mcu_fd_sc_mcu7t5v0__fill_1
XPHY_EDGE_ROW_7_Right_7 VPWR VGND gf180mcu_fd_sc_mcu7t5v0__endcap
XFILLER_14_26 VPWR VPWR VGND VGND gf180mcu_fd_sc_mcu7t5v0__fillcap_4
XFILLER_44_102 VPWR VPWR VGND VGND gf180mcu_fd_sc_mcu7t5v0__fill_2
X_610_ _610_/D _625_/RN _626_/CLK _610_/Q VPWR VPWR VGND VGND gf180mcu_fd_sc_mcu7t5v0__dffrnq_1
X_541_ _541_/A1 _541_/A2 _541_/A3 _541_/B _542_/A4 VPWR VPWR VGND VGND gf180mcu_fd_sc_mcu7t5v0__oai31_1
XFILLER_29_176 VPWR VPWR VGND VGND gf180mcu_fd_sc_mcu7t5v0__fillcap_4
X_472_ _515_/B _498_/A3 _515_/C _473_/A2 VPWR VPWR VGND VGND gf180mcu_fd_sc_mcu7t5v0__nand3_1
XFILLER_41_68 VPWR VPWR VGND VGND gf180mcu_fd_sc_mcu7t5v0__fill_2
Xrebuffer54 _620_/Q _378_/A1 VPWR VPWR VGND VGND gf180mcu_fd_sc_mcu7t5v0__buf_8
X_455_ _430_/I _456_/A2 _456_/A3 wire5/I VPWR VPWR VGND VGND gf180mcu_fd_sc_mcu7t5v0__nor3_4
X_524_ _524_/A1 _524_/A2 _524_/A3 _525_/A3 VPWR VPWR VGND VGND gf180mcu_fd_sc_mcu7t5v0__nand3_1
XFILLER_17_179 VPWR VPWR VGND VGND gf180mcu_fd_sc_mcu7t5v0__fill_2
X_386_ _386_/A1 _505_/B _386_/B _530_/B VPWR VPWR VGND VGND gf180mcu_fd_sc_mcu7t5v0__oai21_4
XFILLER_47_2 VPWR VPWR VGND VGND gf180mcu_fd_sc_mcu7t5v0__fill_1
X_369_ _369_/A1 _369_/A2 _369_/B _534_/B VPWR VPWR VGND VGND gf180mcu_fd_sc_mcu7t5v0__aoi21_1
X_438_ wire42/I _538_/B _444_/A2 _445_/A2 _440_/A3 VPWR VPWR VGND VGND gf180mcu_fd_sc_mcu7t5v0__aoi22_2
X_507_ _507_/A1 _507_/A2 _528_/B _507_/C _512_/A3 VPWR VPWR VGND VGND gf180mcu_fd_sc_mcu7t5v0__aoi211_2
XFILLER_3_72 VPWR VPWR VGND VGND gf180mcu_fd_sc_mcu7t5v0__fillcap_64
XFILLER_9_142 VPWR VPWR VGND VGND gf180mcu_fd_sc_mcu7t5v0__fillcap_32
XFILLER_47_12 VPWR VPWR VGND VGND gf180mcu_fd_sc_mcu7t5v0__fillcap_4
XFILLER_22_37 VPWR VPWR VGND VGND gf180mcu_fd_sc_mcu7t5v0__fill_1
XFILLER_6_101 VPWR VPWR VGND VGND gf180mcu_fd_sc_mcu7t5v0__fillcap_4
XFILLER_23_80 VPWR VPWR VGND VGND gf180mcu_fd_sc_mcu7t5v0__fillcap_4
XFILLER_2_181 VPWR VPWR VGND VGND gf180mcu_fd_sc_mcu7t5v0__fill_1
XFILLER_47_144 VPWR VPWR VGND VGND gf180mcu_fd_sc_mcu7t5v0__fill_1
XFILLER_38_177 VPWR VPWR VGND VGND gf180mcu_fd_sc_mcu7t5v0__fillcap_4
XFILLER_39_35 VPWR VPWR VGND VGND gf180mcu_fd_sc_mcu7t5v0__fill_2
X_540_ _540_/A1 _540_/A2 _544_/A2 VPWR VPWR VGND VGND gf180mcu_fd_sc_mcu7t5v0__nor2_1
X_471_ _501_/A2 _471_/A2 _471_/B _479_/A4 VPWR VPWR VGND VGND gf180mcu_fd_sc_mcu7t5v0__oai21_1
XFILLER_35_147 VPWR VPWR VGND VGND gf180mcu_fd_sc_mcu7t5v0__fill_1
Xwire8 wire8/I wire8/Z VPWR VPWR VGND VGND gf180mcu_fd_sc_mcu7t5v0__clkbuf_1
Xrebuffer55 _331_/B _328_/B VPWR VPWR VGND VGND gf180mcu_fd_sc_mcu7t5v0__buf_8
X_454_ _448_/I _454_/A2 T[4] VPWR VPWR VGND VGND gf180mcu_fd_sc_mcu7t5v0__nor2_4
X_523_ _541_/A1 _486_/B _523_/B1 _444_/B _524_/A1 VPWR VPWR VGND VGND gf180mcu_fd_sc_mcu7t5v0__aoi22_1
X_385_ _505_/A1 _385_/A2 _480_/A2 _386_/B VPWR VPWR VGND VGND gf180mcu_fd_sc_mcu7t5v0__nand3_4
XFILLER_17_158 VPWR VPWR VGND VGND gf180mcu_fd_sc_mcu7t5v0__fillcap_4
XFILLER_11_28 VPWR VPWR VGND VGND gf180mcu_fd_sc_mcu7t5v0__fill_1
XFILLER_7_2 VPWR VPWR VGND VGND gf180mcu_fd_sc_mcu7t5v0__fillcap_64
X_299_ _328_/B _319_/A1 VPWR VPWR VGND VGND gf180mcu_fd_sc_mcu7t5v0__clkinv_1
X_368_ _541_/A2 _532_/A1 _365_/Z _369_/A2 VPWR VPWR VGND VGND gf180mcu_fd_sc_mcu7t5v0__nor3_1
X_506_ _500_/B _506_/A2 _506_/B _506_/C _507_/C VPWR VPWR VGND VGND gf180mcu_fd_sc_mcu7t5v0__oai211_1
X_437_ _444_/A1 _445_/A2 _539_/B VPWR VPWR VGND VGND gf180mcu_fd_sc_mcu7t5v0__nand2_1
XPHY_EDGE_ROW_29_Right_29 VPWR VGND gf180mcu_fd_sc_mcu7t5v0__endcap
XPHY_EDGE_ROW_47_Right_47 VPWR VGND gf180mcu_fd_sc_mcu7t5v0__endcap
XPHY_EDGE_ROW_38_Right_38 VPWR VGND gf180mcu_fd_sc_mcu7t5v0__endcap
XFILLER_33_48 VPWR VPWR VGND VGND gf180mcu_fd_sc_mcu7t5v0__fill_2
XPHY_EDGE_ROW_29_Left_78 VPWR VGND gf180mcu_fd_sc_mcu7t5v0__endcap
XFILLER_2_171 VPWR VPWR VGND VGND gf180mcu_fd_sc_mcu7t5v0__fillcap_4
XFILLER_9_50 VPWR VPWR VGND VGND gf180mcu_fd_sc_mcu7t5v0__fill_2
XFILLER_9_72 VPWR VPWR VGND VGND gf180mcu_fd_sc_mcu7t5v0__fill_2
XFILLER_28_37 VPWR VPWR VGND VGND gf180mcu_fd_sc_mcu7t5v0__fill_2
XFILLER_22_2 VPWR VPWR VGND VGND gf180mcu_fd_sc_mcu7t5v0__fill_1
XFILLER_44_104 VPWR VPWR VGND VGND gf180mcu_fd_sc_mcu7t5v0__fill_1
XFILLER_38_167 VPWR VPWR VGND VGND gf180mcu_fd_sc_mcu7t5v0__fillcap_8
X_599_ _599_/A1 _599_/A2 _599_/Z VPWR VPWR VGND VGND gf180mcu_fd_sc_mcu7t5v0__xor2_1
X_470_ _483_/B _476_/I1 _505_/C _471_/A2 VPWR VPWR VGND VGND gf180mcu_fd_sc_mcu7t5v0__nand3_1
XFILLER_43_181 VPWR VPWR VGND VGND gf180mcu_fd_sc_mcu7t5v0__fill_1
XFILLER_34_181 VPWR VPWR VGND VGND gf180mcu_fd_sc_mcu7t5v0__fill_1
XPHY_EDGE_ROW_16_Left_65 VPWR VGND gf180mcu_fd_sc_mcu7t5v0__endcap
Xrebuffer56 _499_/B _383_/A1 VPWR VPWR VGND VGND gf180mcu_fd_sc_mcu7t5v0__buf_8
X_453_ _456_/A1 _456_/A2 _453_/A3 T[3] VPWR VPWR VGND VGND gf180mcu_fd_sc_mcu7t5v0__and3_4
XFILLER_40_140 VPWR VPWR VGND VGND gf180mcu_fd_sc_mcu7t5v0__fill_1
XFILLER_32_107 VPWR VPWR VGND VGND gf180mcu_fd_sc_mcu7t5v0__fillcap_4
X_384_ _338_/Z _476_/I1 _474_/A2 VPWR VPWR VGND VGND gf180mcu_fd_sc_mcu7t5v0__nor2_1
X_522_ _515_/C _395_/Z _523_/B1 VPWR VPWR VGND VGND gf180mcu_fd_sc_mcu7t5v0__nand2_1
XFILLER_11_18 VPWR VPWR VGND VGND gf180mcu_fd_sc_mcu7t5v0__fillcap_8
XFILLER_16_181 VPWR VPWR VGND VGND gf180mcu_fd_sc_mcu7t5v0__fill_1
XFILLER_14_118 VPWR VPWR VGND VGND gf180mcu_fd_sc_mcu7t5v0__fillcap_32
X_436_ _436_/A1 _432_/Z _531_/A1 _436_/A4 _447_/A2 VPWR VPWR VGND VGND gf180mcu_fd_sc_mcu7t5v0__nand4_2
X_505_ _505_/A1 _505_/A2 _505_/B _505_/C _508_/C1 VPWR VPWR VGND VGND gf180mcu_fd_sc_mcu7t5v0__oai211_1
X_367_ _498_/A3 _500_/B _491_/A2 VPWR VPWR VGND VGND gf180mcu_fd_sc_mcu7t5v0__nand2_1
X_419_ _314_/Z _420_/A2 _321_/Z _496_/B1 VPWR VPWR VGND VGND gf180mcu_fd_sc_mcu7t5v0__nor3_4
XTAP_TAPCELL_ROW_40_200 VPWR VGND gf180mcu_fd_sc_mcu7t5v0__filltie
XFILLER_33_38 VPWR VPWR VGND VGND gf180mcu_fd_sc_mcu7t5v0__fill_2
XPHY_EDGE_ROW_4_Left_53 VPWR VGND gf180mcu_fd_sc_mcu7t5v0__endcap
XPHY_EDGE_ROW_46_Left_95 VPWR VGND gf180mcu_fd_sc_mcu7t5v0__endcap
XPHY_EDGE_ROW_30_Left_79 VPWR VGND gf180mcu_fd_sc_mcu7t5v0__endcap
XFILLER_14_18 VPWR VPWR VGND VGND gf180mcu_fd_sc_mcu7t5v0__fillcap_8
XFILLER_15_2 VPWR VPWR VGND VGND gf180mcu_fd_sc_mcu7t5v0__fillcap_16
X_598_ _623_/Q _624_/Q _598_/A3 _606_/A3 VPWR VPWR VGND VGND gf180mcu_fd_sc_mcu7t5v0__nand3_1
Xrebuffer57 _383_/A1 _505_/B VPWR VPWR VGND VGND gf180mcu_fd_sc_mcu7t5v0__buf_8
X_452_ _452_/A1 _456_/A1 T[2] VPWR VPWR VGND VGND gf180mcu_fd_sc_mcu7t5v0__nor2_4
XFILLER_41_108 VPWR VPWR VGND VGND gf180mcu_fd_sc_mcu7t5v0__fill_1
XFILLER_34_171 VPWR VPWR VGND VGND gf180mcu_fd_sc_mcu7t5v0__fillcap_4
X_521_ _532_/A1 _478_/B _486_/B _521_/B2 _524_/A2 VPWR VPWR VGND VGND gf180mcu_fd_sc_mcu7t5v0__aoi22_1
X_383_ _383_/A1 _386_/A1 _532_/B2 VPWR VPWR VGND VGND gf180mcu_fd_sc_mcu7t5v0__nor2_4
XPHY_EDGE_ROW_33_Left_82 VPWR VGND gf180mcu_fd_sc_mcu7t5v0__endcap
XFILLER_16_160 VPWR VPWR VGND VGND gf180mcu_fd_sc_mcu7t5v0__fillcap_8
XTAP_TAPCELL_ROW_32_180 VPWR VGND gf180mcu_fd_sc_mcu7t5v0__filltie
X_504_ wire18/I _504_/A2 _504_/B1 _504_/B2 _504_/C _506_/C VPWR VPWR VGND VGND gf180mcu_fd_sc_mcu7t5v0__aoi221_1
X_366_ _620_/Q _378_/A2 _332_/Z _500_/B VPWR VPWR VGND VGND gf180mcu_fd_sc_mcu7t5v0__nand3_2
X_435_ _521_/B2 _526_/A3 _486_/B _436_/A4 VPWR VPWR VGND VGND gf180mcu_fd_sc_mcu7t5v0__oai21_1
XTAP_TAPCELL_ROW_9_123 VPWR VGND gf180mcu_fd_sc_mcu7t5v0__filltie
XFILLER_13_174 VPWR VPWR VGND VGND gf180mcu_fd_sc_mcu7t5v0__fillcap_8
XTAP_TAPCELL_ROW_6_115 VPWR VGND gf180mcu_fd_sc_mcu7t5v0__filltie
XFILLER_10_177 VPWR VPWR VGND VGND gf180mcu_fd_sc_mcu7t5v0__fillcap_4
XTAP_TAPCELL_ROW_20_150 VPWR VGND gf180mcu_fd_sc_mcu7t5v0__filltie
XFILLER_45_2 VPWR VPWR VGND VGND gf180mcu_fd_sc_mcu7t5v0__fill_2
X_418_ _439_/A2 _538_/A3 _501_/B _440_/A1 VPWR VPWR VGND VGND gf180mcu_fd_sc_mcu7t5v0__oai21_2
X_349_ _346_/B _505_/A1 _485_/B2 _338_/Z _527_/B1 VPWR VPWR VGND VGND gf180mcu_fd_sc_mcu7t5v0__nand4_4
XFILLER_17_18 VPWR VPWR VGND VGND gf180mcu_fd_sc_mcu7t5v0__fill_2
XTAP_TAPCELL_ROW_40_201 VPWR VGND gf180mcu_fd_sc_mcu7t5v0__filltie
XFILLER_28_39 VPWR VPWR VGND VGND gf180mcu_fd_sc_mcu7t5v0__fill_1
XFILLER_9_52 VPWR VPWR VGND VGND gf180mcu_fd_sc_mcu7t5v0__fill_1
X_597_ _592_/Z _605_/A2 _597_/B _601_/A1 VPWR VPWR VGND VGND gf180mcu_fd_sc_mcu7t5v0__oai21_1
X_520_ _532_/B1 _541_/A3 _494_/Z _478_/B _519_/Z _474_/B _524_/A3 VPWR VPWR VGND VGND
+ gf180mcu_fd_sc_mcu7t5v0__aoi222_2
Xrebuffer58 _572_/A1 _328_/A1 VPWR VPWR VGND VGND gf180mcu_fd_sc_mcu7t5v0__buf_8
X_451_ _430_/I _452_/A1 T[1] VPWR VPWR VGND VGND gf180mcu_fd_sc_mcu7t5v0__nor2_4
XFILLER_31_72 VPWR VPWR VGND VGND gf180mcu_fd_sc_mcu7t5v0__fill_2
X_382_ _476_/S _483_/A2 _503_/A1 VPWR VPWR VGND VGND gf180mcu_fd_sc_mcu7t5v0__nand2_1
XTAP_TAPCELL_ROW_18_145 VPWR VGND gf180mcu_fd_sc_mcu7t5v0__filltie
XFILLER_16_172 VPWR VPWR VGND VGND gf180mcu_fd_sc_mcu7t5v0__fill_2
XTAP_TAPCELL_ROW_47_218 VPWR VGND gf180mcu_fd_sc_mcu7t5v0__filltie
X_503_ _503_/A1 _503_/A2 _503_/B _510_/B VPWR VPWR VGND VGND gf180mcu_fd_sc_mcu7t5v0__aoi21_1
XTAP_TAPCELL_ROW_32_181 VPWR VGND gf180mcu_fd_sc_mcu7t5v0__filltie
X_365_ _620_/Q _378_/A2 _332_/Z _365_/Z VPWR VPWR VGND VGND gf180mcu_fd_sc_mcu7t5v0__and3_1
X_434_ _526_/A3 _486_/B _535_/A1 VPWR VPWR VGND VGND gf180mcu_fd_sc_mcu7t5v0__nand2_1
XFILLER_9_135 VPWR VPWR VGND VGND gf180mcu_fd_sc_mcu7t5v0__fillcap_4
XTAP_TAPCELL_ROW_9_124 VPWR VGND gf180mcu_fd_sc_mcu7t5v0__filltie
XFILLER_13_131 VPWR VPWR VGND VGND gf180mcu_fd_sc_mcu7t5v0__fillcap_8
XFILLER_13_142 VPWR VPWR VGND VGND gf180mcu_fd_sc_mcu7t5v0__fillcap_32
XTAP_TAPCELL_ROW_6_116 VPWR VGND gf180mcu_fd_sc_mcu7t5v0__filltie
XTAP_TAPCELL_ROW_20_151 VPWR VGND gf180mcu_fd_sc_mcu7t5v0__filltie
X_417_ _439_/A2 _445_/A2 _537_/A1 VPWR VPWR VGND VGND gf180mcu_fd_sc_mcu7t5v0__nand2_1
XPHY_EDGE_ROW_25_Right_25 VPWR VGND gf180mcu_fd_sc_mcu7t5v0__endcap
XFILLER_5_2 VPWR VPWR VGND VGND gf180mcu_fd_sc_mcu7t5v0__fillcap_64
X_348_ _515_/A2 _348_/A2 _505_/A2 _541_/A1 VPWR VPWR VGND VGND gf180mcu_fd_sc_mcu7t5v0__nor3_4
XPHY_EDGE_ROW_16_Right_16 VPWR VGND gf180mcu_fd_sc_mcu7t5v0__endcap
XPHY_EDGE_ROW_43_Right_43 VPWR VGND gf180mcu_fd_sc_mcu7t5v0__endcap
XPHY_EDGE_ROW_34_Right_34 VPWR VGND gf180mcu_fd_sc_mcu7t5v0__endcap
XTAP_TAPCELL_ROW_3_108 VPWR VGND gf180mcu_fd_sc_mcu7t5v0__filltie
XTAP_TAPCELL_ROW_40_202 VPWR VGND gf180mcu_fd_sc_mcu7t5v0__filltie
XFILLER_47_115 VPWR VPWR VGND VGND gf180mcu_fd_sc_mcu7t5v0__fill_2
XFILLER_46_181 VPWR VPWR VGND VGND gf180mcu_fd_sc_mcu7t5v0__fill_1
XTAP_TAPCELL_ROW_39_198 VPWR VGND gf180mcu_fd_sc_mcu7t5v0__filltie
XFILLER_37_181 VPWR VPWR VGND VGND gf180mcu_fd_sc_mcu7t5v0__fill_1
XPHY_EDGE_ROW_2_Right_2 VPWR VGND gf180mcu_fd_sc_mcu7t5v0__endcap
X_596_ _609_/A1 _596_/A2 _596_/B _623_/D VPWR VPWR VGND VGND gf180mcu_fd_sc_mcu7t5v0__oai21_1
XFILLER_28_181 VPWR VPWR VGND VGND gf180mcu_fd_sc_mcu7t5v0__fill_1
XFILLER_20_85 VPWR VPWR VGND VGND gf180mcu_fd_sc_mcu7t5v0__fill_2
Xrebuffer59 _442_/A2 _456_/A2 VPWR VPWR VGND VGND gf180mcu_fd_sc_mcu7t5v0__buf_8
XFILLER_26_107 VPWR VPWR VGND VGND gf180mcu_fd_sc_mcu7t5v0__fill_1
XFILLER_20_2 VPWR VPWR VGND VGND gf180mcu_fd_sc_mcu7t5v0__fillcap_8
X_450_ _450_/A1 _450_/A2 _452_/A1 VPWR VPWR VGND VGND gf180mcu_fd_sc_mcu7t5v0__nand2_2
XTAP_TAPCELL_ROW_27_168 VPWR VGND gf180mcu_fd_sc_mcu7t5v0__filltie
X_381_ _346_/B _505_/A1 _381_/A3 _499_/B VPWR VPWR VGND VGND gf180mcu_fd_sc_mcu7t5v0__nand3_4
XFILLER_17_129 VPWR VPWR VGND VGND gf180mcu_fd_sc_mcu7t5v0__fill_1
X_579_ _561_/B _577_/Z _579_/B _621_/D VPWR VPWR VGND VGND gf180mcu_fd_sc_mcu7t5v0__oai21_1
XTAP_TAPCELL_ROW_18_146 VPWR VGND gf180mcu_fd_sc_mcu7t5v0__filltie
XTAP_TAPCELL_ROW_47_219 VPWR VGND gf180mcu_fd_sc_mcu7t5v0__filltie
X_502_ _321_/Z _364_/B _332_/Z _338_/Z _503_/A2 VPWR VPWR VGND VGND gf180mcu_fd_sc_mcu7t5v0__nand4_1
XTAP_TAPCELL_ROW_32_182 VPWR VGND gf180mcu_fd_sc_mcu7t5v0__filltie
X_433_ _531_/A1 _432_/Z _543_/A3 VPWR VPWR VGND VGND gf180mcu_fd_sc_mcu7t5v0__nand2_1
X_364_ _364_/A1 _500_/A2 _364_/B _364_/C _532_/A1 VPWR VPWR VGND VGND gf180mcu_fd_sc_mcu7t5v0__aoi211_4
XFILLER_3_66 VPWR VPWR VGND VGND gf180mcu_fd_sc_mcu7t5v0__fillcap_4
XTAP_TAPCELL_ROW_15_138 VPWR VGND gf180mcu_fd_sc_mcu7t5v0__filltie
XTAP_TAPCELL_ROW_6_117 VPWR VGND gf180mcu_fd_sc_mcu7t5v0__filltie
XFILLER_37_94 VPWR VPWR VGND VGND gf180mcu_fd_sc_mcu7t5v0__fill_2
XFILLER_37_72 VPWR VPWR VGND VGND gf180mcu_fd_sc_mcu7t5v0__fillcap_4
X_347_ _388_/B _527_/A2 _412_/A1 VPWR VPWR VGND VGND gf180mcu_fd_sc_mcu7t5v0__nor2_2
X_416_ _538_/B _538_/A3 _445_/A2 _444_/A2 _428_/A3 VPWR VPWR VGND VGND gf180mcu_fd_sc_mcu7t5v0__aoi22_2
XTAP_TAPCELL_ROW_20_152 VPWR VGND gf180mcu_fd_sc_mcu7t5v0__filltie
XTAP_TAPCELL_ROW_3_109 VPWR VGND gf180mcu_fd_sc_mcu7t5v0__filltie
XFILLER_23_30 VPWR VPWR VGND VGND gf180mcu_fd_sc_mcu7t5v0__fill_1
XFILLER_9_87 VPWR VPWR VGND VGND gf180mcu_fd_sc_mcu7t5v0__fillcap_32
XFILLER_47_138 VPWR VPWR VGND VGND gf180mcu_fd_sc_mcu7t5v0__fill_2
XPHY_EDGE_ROW_8_Left_57 VPWR VGND gf180mcu_fd_sc_mcu7t5v0__endcap
XTAP_TAPCELL_ROW_39_199 VPWR VGND gf180mcu_fd_sc_mcu7t5v0__filltie
XFILLER_29_116 VPWR VPWR VGND VGND gf180mcu_fd_sc_mcu7t5v0__fill_2
XFILLER_43_163 VPWR VPWR VGND VGND gf180mcu_fd_sc_mcu7t5v0__fillcap_16
X_595_ _623_/Q _561_/B _596_/B VPWR VPWR VGND VGND gf180mcu_fd_sc_mcu7t5v0__nand2_1
XFILLER_35_108 VPWR VPWR VGND VGND gf180mcu_fd_sc_mcu7t5v0__fill_2
XFILLER_13_2 VPWR VPWR VGND VGND gf180mcu_fd_sc_mcu7t5v0__fillcap_16
XFILLER_40_177 VPWR VPWR VGND VGND gf180mcu_fd_sc_mcu7t5v0__fillcap_4
XTAP_TAPCELL_ROW_27_169 VPWR VGND gf180mcu_fd_sc_mcu7t5v0__filltie
X_380_ _505_/A1 _385_/A2 _476_/I1 VPWR VPWR VGND VGND gf180mcu_fd_sc_mcu7t5v0__nand2_1
X_578_ _621_/Q _561_/B _579_/B VPWR VPWR VGND VGND gf180mcu_fd_sc_mcu7t5v0__nand2_1
XFILLER_16_174 VPWR VPWR VGND VGND gf180mcu_fd_sc_mcu7t5v0__fill_1
XTAP_TAPCELL_ROW_18_147 VPWR VGND gf180mcu_fd_sc_mcu7t5v0__filltie
.ends
