* NGSPICE file created from dac_5_3.ext - technology: gf180mcuD

.subckt ppolyf_u_1k_9VNAQZ a_40_n2122# a_n440_2000# a_n440_n2122# a_40_2000# VSUBS
X0 a_40_2000# a_40_n2122# VSUBS ppolyf_u_1k r_width=2u r_length=20u
X1 a_n440_2000# a_n440_n2122# VSUBS ppolyf_u_1k r_width=2u r_length=20u
.ends

.subckt ppolyf_u_1k_9VZ9QZ a_n920_2000# a_520_2000# a_n1400_n2122# a_40_n2122# a_n440_2000#
+ a_1000_n2122# a_n440_n2122# a_n920_n2122# a_n1400_2000# a_40_2000# a_520_n2122#
+ a_1000_2000# VSUBS
X0 a_40_2000# a_40_n2122# VSUBS ppolyf_u_1k r_width=2u r_length=20u
X1 a_n1400_2000# a_n1400_n2122# VSUBS ppolyf_u_1k r_width=2u r_length=20u
X2 a_1000_2000# a_1000_n2122# VSUBS ppolyf_u_1k r_width=2u r_length=20u
X3 a_520_2000# a_520_n2122# VSUBS ppolyf_u_1k r_width=2u r_length=20u
X4 a_n440_2000# a_n440_n2122# VSUBS ppolyf_u_1k r_width=2u r_length=20u
X5 a_n920_2000# a_n920_n2122# VSUBS ppolyf_u_1k r_width=2u r_length=20u
.ends

.subckt dac_sub_therm1 T[4] T[5] T[6] m1_1149_4361# m1_189_4361# m1_669_4361# DAC_5_3_OUT
+ VSUBS
Xppolyf_u_1k_9VZ9QZ_0 m1_669_4361# m1_669_4361# DAC_5_3_OUT T[4] m1_1149_4361# T[6]
+ DAC_5_3_OUT DAC_5_3_OUT m1_189_4361# m1_1149_4361# T[5] m1_189_4361# VSUBS ppolyf_u_1k_9VZ9QZ
.ends

.subckt ppolyf_u_1k_9D8AQZ a_n920_2000# a_n1880_2000# a_520_2000# a_n1400_n2122# a_40_n2122#
+ a_n440_2000# a_1480_2000# a_1000_n2122# a_n440_n2122# a_n920_n2122# a_n1400_2000#
+ a_n1880_n2122# a_40_2000# a_520_n2122# a_1480_n2122# a_1000_2000# VSUBS
X0 a_40_2000# a_40_n2122# VSUBS ppolyf_u_1k r_width=2u r_length=20u
X1 a_1480_2000# a_1480_n2122# VSUBS ppolyf_u_1k r_width=2u r_length=20u
X2 a_n1400_2000# a_n1400_n2122# VSUBS ppolyf_u_1k r_width=2u r_length=20u
X3 a_1000_2000# a_1000_n2122# VSUBS ppolyf_u_1k r_width=2u r_length=20u
X4 a_n1880_2000# a_n1880_n2122# VSUBS ppolyf_u_1k r_width=2u r_length=20u
X5 a_520_2000# a_520_n2122# VSUBS ppolyf_u_1k r_width=2u r_length=20u
X6 a_n440_2000# a_n440_n2122# VSUBS ppolyf_u_1k r_width=2u r_length=20u
X7 a_n920_2000# a_n920_n2122# VSUBS ppolyf_u_1k r_width=2u r_length=20u
.ends

.subckt dac_sub_therm2 T[0] T[1] T[2] T[3] DAC_5_3_OUT m1_1629_4361# m1_189_4361#
+ m1_669_4361# m1_1149_4361# VSUBS
Xppolyf_u_1k_9D8AQZ_0 m1_1149_4361# m1_189_4361# m1_1149_4361# T[1] DAC_5_3_OUT m1_1629_4361#
+ m1_189_4361# DAC_5_3_OUT T[3] T[2] m1_669_4361# T[0] m1_1629_4361# DAC_5_3_OUT DAC_5_3_OUT
+ m1_669_4361# VSUBS ppolyf_u_1k_9D8AQZ
.ends

.subckt dac_therm_3_bits dac_sub_therm1_0/T[4] dac_sub_therm2_0/m1_1629_4361# dac_sub_therm1_0/T[5]
+ dac_sub_therm1_0/m1_669_4361# dac_sub_therm1_0/T[6] dac_sub_therm1_0/m1_189_4361#
+ dac_sub_therm2_0/m1_189_4361# dac_sub_therm1_0/m1_1149_4361# dac_sub_therm2_0/m1_1149_4361#
+ dac_sub_therm2_0/DAC_5_3_OUT dac_sub_therm2_0/T[0] dac_sub_therm2_0/T[1] dac_sub_therm2_0/m1_669_4361#
+ dac_sub_therm2_0/T[2] dac_sub_therm2_0/T[3] VSUBS
Xdac_sub_therm1_0 dac_sub_therm1_0/T[4] dac_sub_therm1_0/T[5] dac_sub_therm1_0/T[6]
+ dac_sub_therm1_0/m1_1149_4361# dac_sub_therm1_0/m1_189_4361# dac_sub_therm1_0/m1_669_4361#
+ dac_sub_therm2_0/DAC_5_3_OUT VSUBS dac_sub_therm1
Xdac_sub_therm2_0 dac_sub_therm2_0/T[0] dac_sub_therm2_0/T[1] dac_sub_therm2_0/T[2]
+ dac_sub_therm2_0/T[3] dac_sub_therm2_0/DAC_5_3_OUT dac_sub_therm2_0/m1_1629_4361#
+ dac_sub_therm2_0/m1_189_4361# dac_sub_therm2_0/m1_669_4361# dac_sub_therm2_0/m1_1149_4361#
+ VSUBS dac_sub_therm2
.ends

.subckt ppolyf_u_1k_GR4QPH a_11320_2000# a_n11932_n2334# a_4120_2000# a_n11720_n2122#
+ a_n11720_2000# a_11320_n2122# a_4120_n2122#
X0 a_n11720_2000# a_n11720_n2122# a_n11932_n2334# ppolyf_u_1k r_width=2u r_length=20u
X1 a_11320_2000# a_11320_n2122# a_n11932_n2334# ppolyf_u_1k r_width=2u r_length=20u
X2 a_4120_2000# a_4120_n2122# a_n11932_n2334# ppolyf_u_1k r_width=2u r_length=20u
.ends

.subckt ppolyf_u_1k_RUZ9QZ a_n920_2000# a_520_2000# a_n1400_n2122# a_40_n2122# a_n440_2000#
+ a_1000_n2122# a_n440_n2122# a_n920_n2122# a_n1400_2000# a_40_2000# a_520_n2122#
+ a_1000_2000# VSUBS
X0 a_40_2000# a_40_n2122# VSUBS ppolyf_u_1k r_width=2u r_length=20u
X1 a_n1400_2000# a_n1400_n2122# VSUBS ppolyf_u_1k r_width=2u r_length=20u
X2 a_1000_2000# a_1000_n2122# VSUBS ppolyf_u_1k r_width=2u r_length=20u
X3 a_520_2000# a_520_n2122# VSUBS ppolyf_u_1k r_width=2u r_length=20u
X4 a_n440_2000# a_n440_n2122# VSUBS ppolyf_u_1k r_width=2u r_length=20u
X5 a_n920_2000# a_n920_n2122# VSUBS ppolyf_u_1k r_width=2u r_length=20u
.ends

.subckt dac_sub_r2r in R_node_out R_node_in net2 net1 net3 VSUBS
Xppolyf_u_1k_RUZ9QZ_0 net2 net2 R_node_in in net1 R_node_out R_node_in R_node_in net3
+ net1 R_node_out net3 VSUBS ppolyf_u_1k_RUZ9QZ
.ends

.subckt dac_r2r_5_bits dac_sub_r2r_2/net2 dac_sub_r2r_2/net1 dac_sub_r2r_2/in dac_sub_r2r_4/in
+ dac_sub_r2r_3/net1 dac_sub_r2r_1/in dac_sub_r2r_0/net2 dac_sub_r2r_3/net3 dac_sub_r2r_2/R_node_in
+ dac_sub_r2r_3/R_node_in dac_sub_r2r_2/net3 dac_sub_r2r_3/net2 dac_sub_r2r_4/net2
+ dac_sub_r2r_4/net3 dac_sub_r2r_3/in dac_sub_r2r_1/net2 dac_sub_r2r_0/in dac_sub_r2r_1/net1
+ dac_sub_r2r_4/R_node_out dac_sub_r2r_0/net3 dac_sub_r2r_1/net3 dac_sub_r2r_0/R_node_in
+ dac_sub_r2r_1/R_node_in VSUBS dac_sub_r2r_4/net1
Xdac_sub_r2r_0 dac_sub_r2r_0/in dac_sub_r2r_1/R_node_in dac_sub_r2r_0/R_node_in dac_sub_r2r_0/net2
+ dac_sub_r2r_0/net1 dac_sub_r2r_0/net3 VSUBS dac_sub_r2r
Xdac_sub_r2r_1 dac_sub_r2r_1/in dac_sub_r2r_2/R_node_in dac_sub_r2r_1/R_node_in dac_sub_r2r_1/net2
+ dac_sub_r2r_1/net1 dac_sub_r2r_1/net3 VSUBS dac_sub_r2r
Xdac_sub_r2r_2 dac_sub_r2r_2/in dac_sub_r2r_3/R_node_in dac_sub_r2r_2/R_node_in dac_sub_r2r_2/net2
+ dac_sub_r2r_2/net1 dac_sub_r2r_2/net3 VSUBS dac_sub_r2r
Xdac_sub_r2r_3 dac_sub_r2r_3/in dac_sub_r2r_4/R_node_in dac_sub_r2r_3/R_node_in dac_sub_r2r_3/net2
+ dac_sub_r2r_3/net1 dac_sub_r2r_3/net3 VSUBS dac_sub_r2r
Xdac_sub_r2r_4 dac_sub_r2r_4/in dac_sub_r2r_4/R_node_out dac_sub_r2r_4/R_node_in dac_sub_r2r_4/net2
+ dac_sub_r2r_4/net1 dac_sub_r2r_4/net3 VSUBS dac_sub_r2r
.ends

.subckt dac_5_3 B[0] B[1] B[2] B[3] B[4] T[0] T[1] T[2] T[3] T[4] T[5] T[6] DAC_OUT
+ VGND
Xppolyf_u_1k_9VNAQZ_0 2R_0G|2R_01|2R_02|2R_0 2R_0G|2R_0G VGND 2R_0G|2R_0G VGND ppolyf_u_1k_9VNAQZ
Xdac_therm_3_bits_0 T[4] 2R_T3|2R_T3 T[5] 2R_T5|2R_T5 T[6] 2R_T6|2R_T6 2R_T0|2R_T0
+ 2R_T4|2R_T4 2R_T2|2R_T2 DAC_OUT T[0] T[1] 2R_T1|2R_T1 T[2] T[3] VGND dac_therm_3_bits
Xppolyf_u_1k_GR4QPH_0 VGND VGND VGND VGND VGND VGND VGND ppolyf_u_1k_GR4QPH
Xdac_r2r_5_bits_0 2R_21|2R21 2R_2|2R2 B[2] B[4] 2R_3|2R_3 B[1] 2R_01|2R_01 2R_32|2R_32
+ 2R_11|2R_12|2R_21|2R_22|2R_2 2R_21|2R22|2R_31|2R_32|2R_3 2R_22|2R22 2R_31|2R_31
+ 2R_41|2R_41 2R_42|2R_42 B[3] 2R_11|2R_11 B[0] 2R_1|2R_1 DAC_OUT 2R_02|2R_02 2R_12|2R_12
+ 2R_0G|2R_01|2R_02|2R_0 2R_01|2R_02|2R_11|2R_12|2R_1 VGND 2R_4|2R_4 dac_r2r_5_bits
.ends
