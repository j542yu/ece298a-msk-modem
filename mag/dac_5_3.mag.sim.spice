* NGSPICE file created from dac_5_3.mag_parax.ext - technology: gf180mcuD

.subckt dac_5_3.mag_parax B[0] B[1] B[2] B[3] B[4] T[0] T[1] T[2] T[3] T[4] T[5] T[6]
+ DAC_5_3_OUT GND
X0 2R_2|2R2 B[2].t0 GND.t28 ppolyf_u_1k r_width=2u r_length=20u
X1 2R_21|2R21 2R_21|2R22|2R_31|2R_32|2R_3 GND.t21 ppolyf_u_1k r_width=2u r_length=20u
X2 2R_T5|2R_T5 DAC_5_3_OUT.t5 GND.t45 ppolyf_u_1k r_width=2u r_length=20u
X3 2R_T4|2R_T4 DAC_5_3_OUT.t4 GND.t41 ppolyf_u_1k r_width=2u r_length=20u
X4 2R_0|2R_0 B[0].t0 GND.t43 ppolyf_u_1k r_width=2u r_length=20u
X5 2R_4|2R_4 2R_31|2R_32|2R_41|2R_42|2R_4 GND.t39 ppolyf_u_1k r_width=2u r_length=20u
X6 2R_4|2R_4 B[4].t0 GND.t31 ppolyf_u_1k r_width=2u r_length=20u
X7 2R_31|2R_31 2R_21|2R22|2R_31|2R_32|2R_3 GND.t42 ppolyf_u_1k r_width=2u r_length=20u
X8 2R_3|2R_3 2R_21|2R22|2R_31|2R_32|2R_3 GND.t4 ppolyf_u_1k r_width=2u r_length=20u
X9 2R_T4|2R_T4 T[4].t0 GND.t16 ppolyf_u_1k r_width=2u r_length=20u
X10 2R_T5|2R_T5 T[5].t0 GND.t40 ppolyf_u_1k r_width=2u r_length=20u
X11 2R_2|2R2 2R_11|2R_12|2R_21|2R_22|2R_2 GND.t35 ppolyf_u_1k r_width=2u r_length=20u
X12 2R_T6|2R_T6 DAC_5_3_OUT.t3 GND.t37 ppolyf_u_1k r_width=2u r_length=20u
X13 2R_42|2R_42 2R_31|2R_32|2R_41|2R_42|2R_4 GND.t10 ppolyf_u_1k r_width=2u r_length=20u
X14 2R_41|2R_41 2R_31|2R_32|2R_41|2R_42|2R_4 GND.t7 ppolyf_u_1k r_width=2u r_length=20u
X15 2R_11|2R_11 2R_01|2R_02|2R_11|2R_12|2R_1 GND.t3 ppolyf_u_1k r_width=2u r_length=20u
X16 2R_1|2R_1 2R_01|2R_02|2R_11|2R_12|2R_1 GND.t11 ppolyf_u_1k r_width=2u r_length=20u
X17 2R_T1|2R_T1 T[1].t0 GND.t15 ppolyf_u_1k r_width=2u r_length=20u
X18 2R_21|2R21 2R_11|2R_12|2R_21|2R_22|2R_2 GND.t38 ppolyf_u_1k r_width=2u r_length=20u
X19 2R_T2|2R_T2 T[2].t0 GND.t12 ppolyf_u_1k r_width=2u r_length=20u
X20 2R_T0|2R_T0 DAC_5_3_OUT.t8 GND.t54 ppolyf_u_1k r_width=2u r_length=20u
X21 2R_02|2R_02 2R_01|2R_02|2R_11|2R_12|2R_1 GND.t30 ppolyf_u_1k r_width=2u r_length=20u
X22 2R_12|2R_12 2R_01|2R_02|2R_11|2R_12|2R_1 GND.t14 ppolyf_u_1k r_width=2u r_length=20u
X23 2R_32|2R_32 2R_21|2R22|2R_31|2R_32|2R_3 GND.t36 ppolyf_u_1k r_width=2u r_length=20u
X24 GND.t1 GND.t2 GND.t0 ppolyf_u_1k r_width=2u r_length=20u
X25 2R_42|2R_42 DAC_5_3_OUT.t0 GND.t22 ppolyf_u_1k r_width=2u r_length=20u
X26 GND.t25 GND.t26 GND.t24 ppolyf_u_1k r_width=2u r_length=20u
X27 2R_12|2R_12 2R_11|2R_12|2R_21|2R_22|2R_2 GND.t9 ppolyf_u_1k r_width=2u r_length=20u
X28 2R_32|2R_32 2R_31|2R_32|2R_41|2R_42|2R_4 GND.t52 ppolyf_u_1k r_width=2u r_length=20u
X29 2R_T0|2R_T0 T[0].t0 GND.t13 ppolyf_u_1k r_width=2u r_length=20u
X30 2R_T6|2R_T6 T[6].t0 GND.t8 ppolyf_u_1k r_width=2u r_length=20u
X31 GND.t49 GND.t50 GND.t48 ppolyf_u_1k r_width=2u r_length=20u
X32 2R_0G|2R_0G GND.t19 GND.t18 ppolyf_u_1k r_width=2u r_length=20u
X33 2R_22|2R22 2R_11|2R_12|2R_21|2R_22|2R_2 GND.t17 ppolyf_u_1k r_width=2u r_length=20u
X34 2R_T2|2R_T2 DAC_5_3_OUT.t7 GND.t47 ppolyf_u_1k r_width=2u r_length=20u
X35 2R_T1|2R_T1 DAC_5_3_OUT.t6 GND.t46 ppolyf_u_1k r_width=2u r_length=20u
X36 2R_02|2R_02 2R_0G|2R_01|2R_02|2R_0 GND.t29 ppolyf_u_1k r_width=2u r_length=20u
X37 2R_22|2R22 2R_21|2R22|2R_31|2R_32|2R_3 GND.t53 ppolyf_u_1k r_width=2u r_length=20u
X38 2R_01|2R_01 2R_01|2R_02|2R_11|2R_12|2R_1 GND.t51 ppolyf_u_1k r_width=2u r_length=20u
X39 2R_41|2R_41 DAC_5_3_OUT.t2 GND.t33 ppolyf_u_1k r_width=2u r_length=20u
X40 2R_1|2R_1 B[1].t0 GND.t44 ppolyf_u_1k r_width=2u r_length=20u
X41 2R_3|2R_3 B[3].t0 GND.t32 ppolyf_u_1k r_width=2u r_length=20u
X42 2R_31|2R_31 2R_31|2R_32|2R_41|2R_42|2R_4 GND.t6 ppolyf_u_1k r_width=2u r_length=20u
X43 2R_11|2R_11 2R_11|2R_12|2R_21|2R_22|2R_2 GND.t27 ppolyf_u_1k r_width=2u r_length=20u
X44 2R_0G|2R_0G 2R_0G|2R_01|2R_02|2R_0 GND.t5 ppolyf_u_1k r_width=2u r_length=20u
X45 2R_01|2R_01 2R_0G|2R_01|2R_02|2R_0 GND.t34 ppolyf_u_1k r_width=2u r_length=20u
X46 2R_0|2R_0 2R_0G|2R_01|2R_02|2R_0 GND.t55 ppolyf_u_1k r_width=2u r_length=20u
X47 2R_T3|2R_T3 T[3].t0 GND.t20 ppolyf_u_1k r_width=2u r_length=20u
X48 2R_T3|2R_T3 DAC_5_3_OUT.t1 GND.t23 ppolyf_u_1k r_width=2u r_length=20u
R0 B[2] B[2].t0 3.61864
R1 GND.n5 GND.n1 1787.75
R2 GND.n5 GND.n0 1785.72
R3 GND.n3 GND.n1 947.409
R4 GND.n3 GND.n0 945.409
R5 GND.t52 GND.t10 274.848
R6 GND.t53 GND.t36 274.848
R7 GND.t8 GND.t48 272.014
R8 GND.t40 GND.t8 272.014
R9 GND.t16 GND.t40 272.014
R10 GND.t41 GND.t16 272.014
R11 GND.t45 GND.t41 272.014
R12 GND.t37 GND.t45 272.014
R13 GND.t54 GND.t37 272.014
R14 GND.t46 GND.t54 272.014
R15 GND.t47 GND.t46 272.014
R16 GND.t23 GND.t47 272.014
R17 GND.t20 GND.t23 272.014
R18 GND.t12 GND.t20 272.014
R19 GND.t15 GND.t12 272.014
R20 GND.t13 GND.t15 272.014
R21 GND.t33 GND.t22 272.014
R22 GND.t31 GND.t33 272.014
R23 GND.t39 GND.t31 272.014
R24 GND.t7 GND.t39 272.014
R25 GND.t10 GND.t7 272.014
R26 GND.t6 GND.t52 272.014
R27 GND.t32 GND.t6 272.014
R28 GND.t4 GND.t32 272.014
R29 GND.t42 GND.t4 272.014
R30 GND.t36 GND.t42 272.014
R31 GND.t21 GND.t53 272.014
R32 GND.t28 GND.t21 272.014
R33 GND.t35 GND.t28 272.014
R34 GND.t38 GND.t35 272.014
R35 GND.t17 GND.t38 272.014
R36 GND.t9 GND.t17 272.014
R37 GND.t27 GND.t9 272.014
R38 GND.t44 GND.t27 272.014
R39 GND.t11 GND.t44 272.014
R40 GND.t3 GND.t11 272.014
R41 GND.t14 GND.t3 272.014
R42 GND.t30 GND.t14 272.014
R43 GND.t51 GND.t30 272.014
R44 GND.t43 GND.t51 272.014
R45 GND.t55 GND.t43 272.014
R46 GND.t34 GND.t55 272.014
R47 GND.t29 GND.t34 272.014
R48 GND.t5 GND.t29 272.014
R49 GND.t18 GND.t5 272.014
R50 GND.t0 GND.t18 272.014
R51 GND.n4 GND.t13 269.748
R52 GND.t22 GND.t24 266.348
R53 GND.t48 GND.n3 213.189
R54 GND.n5 GND.t0 213.189
R55 GND.n2 GND.t49 8.34196
R56 GND.n2 GND.t50 8.34196
R57 GND.n6 GND.t1 8.34196
R58 GND.n0 GND.t25 5.30442
R59 GND.n1 GND.t26 4.87122
R60 GND.n7 GND.t19 4.50913
R61 GND.n8 GND.n6 3.8705
R62 GND.n7 GND.t2 3.57
R63 GND.t24 GND.n4 2.26728
R64 GND.n4 GND.n0 1.73383
R65 GND.n4 GND.n1 1.3005
R66 GND.n8 GND.n7 0.700561
R67 GND GND.n8 0.475045
R68 GND.n3 GND.n2 0.111138
R69 GND.n6 GND.n5 0.111138
R70 DAC_5_3_OUT.n1 DAC_5_3_OUT.t4 4.50913
R71 DAC_5_3_OUT.n0 DAC_5_3_OUT.t0 3.62004
R72 DAC_5_3_OUT.n6 DAC_5_3_OUT.t1 3.61803
R73 DAC_5_3_OUT.n0 DAC_5_3_OUT.t2 3.61682
R74 DAC_5_3_OUT.n5 DAC_5_3_OUT.t7 3.57
R75 DAC_5_3_OUT.n4 DAC_5_3_OUT.t6 3.57
R76 DAC_5_3_OUT.n3 DAC_5_3_OUT.t8 3.57
R77 DAC_5_3_OUT.n2 DAC_5_3_OUT.t3 3.57
R78 DAC_5_3_OUT.n1 DAC_5_3_OUT.t5 3.57
R79 DAC_5_3_OUT.n2 DAC_5_3_OUT.n1 0.93963
R80 DAC_5_3_OUT.n3 DAC_5_3_OUT.n2 0.93963
R81 DAC_5_3_OUT.n4 DAC_5_3_OUT.n3 0.93963
R82 DAC_5_3_OUT.n7 DAC_5_3_OUT.n0 0.862496
R83 DAC_5_3_OUT.n5 DAC_5_3_OUT.n4 0.618515
R84 DAC_5_3_OUT DAC_5_3_OUT.n7 0.240307
R85 DAC_5_3_OUT.n7 DAC_5_3_OUT.n6 0.188
R86 DAC_5_3_OUT.n6 DAC_5_3_OUT.n5 0.0493341
R87 B[0] B[0].t0 3.61864
R88 B[4] B[4].t0 3.61864
R89 T[4] T[4].t0 3.59605
R90 T[5] T[5].t0 3.59605
R91 T[1] T[1].t0 3.59605
R92 T[2] T[2].t0 3.59605
R93 T[0] T[0].t0 3.59605
R94 T[6] T[6].t0 3.59605
R95 B[1] B[1].t0 3.61864
R96 B[3] B[3].t0 3.61864
R97 T[3] T[3].t0 3.59605
C0 2R_42|2R_42 2R_41|2R_41 1.73284f
C1 B[2] 2R_21|2R22|2R_31|2R_32|2R_3 0.04647f
C2 2R_01|2R_02|2R_11|2R_12|2R_1 2R_11|2R_12|2R_21|2R_22|2R_2 0
C3 2R_12|2R_12 2R_01|2R_01 0
C4 2R_T1|2R_T1 2R_T5|2R_T5 0
C5 2R_4|2R_4 2R_31|2R_31 0
C6 2R_21|2R21 2R_2|2R2 0.92631f
C7 T[2] DAC_5_3_OUT 0.3506f
C8 T[4] DAC_5_3_OUT 0.04699f
C9 2R_T2|2R_T2 2R_T0|2R_T0 0.0023f
C10 2R_T3|2R_T3 2R_T1|2R_T1 0.00473f
C11 T[2] T[1] 0.29805f
C12 T[5] T[6] 0.29805f
C13 2R_11|2R_11 2R_12|2R_12 1.73284f
C14 2R_42|2R_42 2R_32|2R_32 0.14633f
C15 2R_T6|2R_T6 2R_T0|2R_T0 0.18829f
C16 2R_4|2R_4 2R_41|2R_41 0.92631f
C17 B[3] 2R_21|2R22|2R_31|2R_32|2R_3 0.04645f
C18 2R_11|2R_11 2R_01|2R_01 0
C19 2R_41|2R_41 2R_31|2R_31 0
C20 2R_T4|2R_T4 2R_T6|2R_T6 0.00734f
C21 2R_0|2R_0 2R_02|2R_02 0.00831f
C22 B[0] 2R_0G|2R_01|2R_02|2R_0 0.04645f
C23 T[2] T[3] 0.29805f
C24 2R_T1|2R_T1 2R_T0|2R_T0 1.71136f
C25 2R_T3|2R_T3 2R_T0|2R_T0 0.00231f
C26 2R_21|2R21 2R_31|2R_31 0
C27 2R_11|2R_12|2R_21|2R_22|2R_2 B[2] 0.04645f
C28 DAC_5_3_OUT T[1] 0.35044f
C29 2R_31|2R_31 2R_32|2R_32 1.73284f
C30 2R_T4|2R_T4 2R_T5|2R_T5 0.9263f
C31 2R_T4|2R_T4 2R_T1|2R_T1 0
C32 2R_11|2R_11 2R_2|2R2 0
C33 2R_31|2R_32|2R_41|2R_42|2R_4 B[3] 0.04647f
C34 2R_21|2R21 2R_22|2R22 1.73284f
C35 2R_12|2R_12 2R_02|2R_02 0.15439f
C36 2R_22|2R22 2R_32|2R_32 0.14633f
C37 2R_02|2R_02 2R_01|2R_01 1.73284f
C38 T[3] DAC_5_3_OUT 0.5667f
C39 2R_01|2R_02|2R_11|2R_12|2R_1 2R_0G|2R_01|2R_02|2R_0 0
C40 2R_01|2R_02|2R_11|2R_12|2R_1 B[0] 0.04647f
C41 B[4] DAC_5_3_OUT 0.22873f
C42 2R_12|2R_12 2R_22|2R22 0.15439f
C43 2R_31|2R_32|2R_41|2R_42|2R_4 DAC_5_3_OUT 0.0025f
C44 2R_21|2R21 2R_32|2R_32 0
C45 2R_3|2R_3 2R_31|2R_31 0.92631f
C46 T[5] T[4] 0.29805f
C47 2R_31|2R_32|2R_41|2R_42|2R_4 2R_21|2R22|2R_31|2R_32|2R_3 0
C48 2R_01|2R_02|2R_11|2R_12|2R_1 B[1] 0.04645f
C49 2R_T1|2R_T1 2R_41|2R_41 0
C50 2R_1|2R_1 2R_12|2R_12 0.00831f
C51 2R_11|2R_11 2R_22|2R22 0
C52 2R_02|2R_02 2R_0G|2R_0G 0.04634f
C53 2R_4|2R_4 2R_42|2R_42 0.00831f
C54 2R_1|2R_1 2R_01|2R_01 0
C55 T[0] DAC_5_3_OUT 0.37068f
C56 2R_2|2R2 2R_22|2R22 0.00831f
C57 2R_11|2R_12|2R_21|2R_22|2R_2 2R_21|2R22|2R_31|2R_32|2R_3 0
C58 2R_0|2R_0 2R_01|2R_01 0.92631f
C59 2R_42|2R_42 2R_31|2R_31 0
C60 2R_T1|2R_T1 2R_T2|2R_T2 1.15162f
C61 2R_31|2R_32|2R_41|2R_42|2R_4 B[4] 0.04645f
C62 T[0] T[1] 0.29805f
C63 2R_11|2R_12|2R_21|2R_22|2R_2 B[1] 0.04647f
C64 2R_T6|2R_T6 2R_T5|2R_T5 1.05132f
C65 2R_T3|2R_T3 2R_T2|2R_T2 0.35649f
C66 2R_T6|2R_T6 2R_T1|2R_T1 0
C67 2R_21|2R21 2R_3|2R_3 0
C68 2R_41|2R_41 2R_T0|2R_T0 0
C69 2R_3|2R_3 2R_32|2R_32 0.00831f
C70 2R_1|2R_1 2R_11|2R_11 0.92631f
C71 2R_21|2R21 2R_11|2R_11 0
C72 T[6] GND 0.87291f
C73 T[5] GND 0.73119f
C74 T[4] GND 0.8262f
C75 T[3] GND 0.76306f
C76 T[2] GND 0.73119f
C77 T[1] GND 0.73119f
C78 T[0] GND 0.93798f
C79 DAC_5_3_OUT GND 8.26364f
C80 B[4] GND 0.67242f
C81 B[3] GND 0.72074f
C82 B[2] GND 0.72073f
C83 B[1] GND 0.72073f
C84 B[0] GND 0.72073f
C85 2R_T4|2R_T4 GND 0.92687f
C86 2R_T5|2R_T5 GND 1.18371f
C87 2R_T6|2R_T6 GND 2.05995f
C88 2R_T3|2R_T3 GND 0.95623f
C89 2R_T2|2R_T2 GND 1.31238f
C90 2R_T1|2R_T1 GND 1.57743f
C91 2R_T0|2R_T0 GND 2.7392f
C92 2R_4|2R_4 GND 0.92678f
C93 2R_41|2R_41 GND 1.13007f
C94 2R_42|2R_42 GND 2.01152f
C95 2R_31|2R_32|2R_41|2R_42|2R_4 GND 2.75137f
C96 2R_3|2R_3 GND 0.92678f
C97 2R_31|2R_31 GND 1.13005f
C98 2R_32|2R_32 GND 1.84021f
C99 2R_21|2R22|2R_31|2R_32|2R_3 GND 2.75137f
C100 2R_2|2R2 GND 0.92678f
C101 2R_21|2R21 GND 1.13005f
C102 2R_22|2R22 GND 1.83907f
C103 2R_11|2R_12|2R_21|2R_22|2R_2 GND 2.74802f
C104 2R_1|2R_1 GND 0.92678f
C105 2R_11|2R_11 GND 1.13005f
C106 2R_12|2R_12 GND 1.83793f
C107 2R_01|2R_02|2R_11|2R_12|2R_1 GND 2.74802f
C108 2R_0|2R_0 GND 0.92678f
C109 2R_01|2R_01 GND 1.13005f
C110 2R_02|2R_02 GND 1.8805f
C111 2R_0G|2R_01|2R_02|2R_0 GND 2.24304f
C112 2R_0G|2R_0G GND 1.12723f
.ends
