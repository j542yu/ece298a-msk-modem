* NGSPICE file created from dac_5_3.ext - technology: gf180mcuD

.subckt ppolyf_u_1k_9VNAQZ a_40_n2122# a_n440_2000# a_n440_n2122# a_40_2000# VSUBS
X0 a_40_2000# a_40_n2122# VSUBS ppolyf_u_1k r_width=2u r_length=20u
X1 a_n440_2000# a_n440_n2122# VSUBS ppolyf_u_1k r_width=2u r_length=20u
.ends

.subckt ppolyf_u_1k_9VZ9QZ a_n920_2000# a_520_2000# a_n1400_n2122# a_40_n2122# a_n440_2000#
+ a_1000_n2122# a_n440_n2122# a_n920_n2122# a_n1400_2000# a_40_2000# a_520_n2122#
+ a_1000_2000# VSUBS
X0 a_40_2000# a_40_n2122# VSUBS ppolyf_u_1k r_width=2u r_length=20u
X1 a_n1400_2000# a_n1400_n2122# VSUBS ppolyf_u_1k r_width=2u r_length=20u
X2 a_1000_2000# a_1000_n2122# VSUBS ppolyf_u_1k r_width=2u r_length=20u
X3 a_520_2000# a_520_n2122# VSUBS ppolyf_u_1k r_width=2u r_length=20u
X4 a_n440_2000# a_n440_n2122# VSUBS ppolyf_u_1k r_width=2u r_length=20u
X5 a_n920_2000# a_n920_n2122# VSUBS ppolyf_u_1k r_width=2u r_length=20u
.ends

.subckt dac_sub_therm1 m1_1149_4361# m1_2109_n111# m1_1629_n111# m1_2589_n111# m1_189_4361#
+ m1_669_4361# m1_189_189# VSUBS
Xppolyf_u_1k_9VZ9QZ_0 m1_669_4361# m1_669_4361# m1_189_189# m1_1629_n111# m1_1149_4361#
+ m1_2589_n111# m1_189_189# m1_189_189# m1_189_4361# m1_1149_4361# m1_2109_n111# m1_189_4361#
+ VSUBS ppolyf_u_1k_9VZ9QZ
.ends

.subckt ppolyf_u_1k_9D8AQZ a_n920_2000# a_n1880_2000# a_520_2000# a_n1400_n2122# a_40_n2122#
+ a_n440_2000# a_1480_2000# a_1000_n2122# a_n440_n2122# a_n920_n2122# a_n1400_2000#
+ a_n1880_n2122# a_40_2000# a_520_n2122# a_1480_n2122# a_1000_2000# VSUBS
X0 a_40_2000# a_40_n2122# VSUBS ppolyf_u_1k r_width=2u r_length=20u
X1 a_1480_2000# a_1480_n2122# VSUBS ppolyf_u_1k r_width=2u r_length=20u
X2 a_n1400_2000# a_n1400_n2122# VSUBS ppolyf_u_1k r_width=2u r_length=20u
X3 a_1000_2000# a_1000_n2122# VSUBS ppolyf_u_1k r_width=2u r_length=20u
X4 a_n1880_2000# a_n1880_n2122# VSUBS ppolyf_u_1k r_width=2u r_length=20u
X5 a_520_2000# a_520_n2122# VSUBS ppolyf_u_1k r_width=2u r_length=20u
X6 a_n440_2000# a_n440_n2122# VSUBS ppolyf_u_1k r_width=2u r_length=20u
X7 a_n920_2000# a_n920_n2122# VSUBS ppolyf_u_1k r_width=2u r_length=20u
.ends

.subckt dac_sub_therm2 m1_1149_n111# m1_1629_n111# m1_669_n111# m1_1629_4361# m1_189_n111#
+ m1_2378_189# m1_189_4361# m1_669_4361# m1_1149_4361# VSUBS
Xppolyf_u_1k_9D8AQZ_0 m1_1149_4361# m1_189_4361# m1_1149_4361# m1_669_n111# m1_2378_189#
+ m1_1629_4361# m1_189_4361# m1_2378_189# m1_1629_n111# m1_1149_n111# m1_669_4361#
+ m1_189_n111# m1_1629_4361# m1_2378_189# m1_2378_189# m1_669_4361# VSUBS ppolyf_u_1k_9D8AQZ
.ends

.subckt dac_therm_3_bits dac_sub_therm1_0/m1_2109_n111# dac_sub_therm2_0/m1_189_n111#
+ dac_sub_therm1_0/m1_1629_n111# dac_sub_therm2_0/m1_1629_4361# dac_sub_therm1_0/m1_669_4361#
+ dac_sub_therm1_0/m1_2589_n111# dac_sub_therm1_0/m1_189_4361# dac_sub_therm2_0/m1_189_4361#
+ dac_sub_therm1_0/m1_1149_4361# dac_sub_therm2_0/m1_1149_4361# m1_n627_300# dac_sub_therm2_0/m1_669_n111#
+ dac_sub_therm2_0/m1_669_4361# dac_sub_therm2_0/m1_1149_n111# dac_sub_therm2_0/m1_1629_n111#
+ VSUBS
Xdac_sub_therm1_0 dac_sub_therm1_0/m1_1149_4361# dac_sub_therm1_0/m1_2109_n111# dac_sub_therm1_0/m1_1629_n111#
+ dac_sub_therm1_0/m1_2589_n111# dac_sub_therm1_0/m1_189_4361# dac_sub_therm1_0/m1_669_4361#
+ m1_n627_300# VSUBS dac_sub_therm1
Xdac_sub_therm2_0 dac_sub_therm2_0/m1_1149_n111# dac_sub_therm2_0/m1_1629_n111# dac_sub_therm2_0/m1_669_n111#
+ dac_sub_therm2_0/m1_1629_4361# dac_sub_therm2_0/m1_189_n111# m1_n627_300# dac_sub_therm2_0/m1_189_4361#
+ dac_sub_therm2_0/m1_669_4361# dac_sub_therm2_0/m1_1149_4361# VSUBS dac_sub_therm2
.ends

.subckt ppolyf_u_1k_GR4QPH a_11320_2000# a_n11932_n2334# a_4120_2000# a_n11720_n2122#
+ a_n11720_2000# a_11320_n2122# a_4120_n2122#
X0 a_n11720_2000# a_n11720_n2122# a_n11932_n2334# ppolyf_u_1k r_width=2u r_length=20u
X1 a_11320_2000# a_11320_n2122# a_n11932_n2334# ppolyf_u_1k r_width=2u r_length=20u
X2 a_4120_2000# a_4120_n2122# a_n11932_n2334# ppolyf_u_1k r_width=2u r_length=20u
.ends

.subckt ppolyf_u_1k_RUZ9QZ a_n920_2000# a_520_2000# a_n1400_n2122# a_40_n2122# a_n440_2000#
+ a_1000_n2122# a_n440_n2122# a_n920_n2122# a_n1400_2000# a_40_2000# a_520_n2122#
+ a_1000_2000# VSUBS
X0 a_40_2000# a_40_n2122# VSUBS ppolyf_u_1k r_width=2u r_length=20u
X1 a_n1400_2000# a_n1400_n2122# VSUBS ppolyf_u_1k r_width=2u r_length=20u
X2 a_1000_2000# a_1000_n2122# VSUBS ppolyf_u_1k r_width=2u r_length=20u
X3 a_520_2000# a_520_n2122# VSUBS ppolyf_u_1k r_width=2u r_length=20u
X4 a_n440_2000# a_n440_n2122# VSUBS ppolyf_u_1k r_width=2u r_length=20u
X5 a_n920_2000# a_n920_n2122# VSUBS ppolyf_u_1k r_width=2u r_length=20u
.ends

.subckt dac_sub_r2r m1_588_4371# m1_127_199# m1_1079_4371# m1_1559_n101# m1_2039_199#
+ m1_120_4390# VSUBS
Xppolyf_u_1k_RUZ9QZ_0 m1_588_4371# m1_588_4371# m1_127_199# m1_1559_n101# m1_1079_4371#
+ m1_2039_199# m1_127_199# m1_127_199# m1_120_4390# m1_1079_4371# m1_2039_199# m1_120_4390#
+ VSUBS ppolyf_u_1k_RUZ9QZ
.ends

.subckt dac_r2r_5_bits dac_sub_r2r_3/m1_1079_4371# dac_sub_r2r_2/m1_1559_n101# dac_sub_r2r_2/m1_1079_4371#
+ dac_sub_r2r_4/m1_2039_199# dac_sub_r2r_1/m1_1079_4371# dac_sub_r2r_0/m1_127_199#
+ dac_sub_r2r_1/m1_1559_n101# dac_sub_r2r_0/m1_588_4371# m1_7682_419# dac_sub_r2r_3/m1_120_4390#
+ dac_sub_r2r_0/m1_1559_n101# dac_sub_r2r_4/m1_588_4371# dac_sub_r2r_2/m1_120_4390#
+ dac_sub_r2r_4/m1_1559_n101# dac_sub_r2r_3/m1_588_4371# dac_sub_r2r_4/m1_120_4390#
+ dac_sub_r2r_0/m1_120_4390# m1_5293_419# dac_sub_r2r_1/m1_120_4390# dac_sub_r2r_1/m1_588_4371#
+ dac_sub_r2r_3/m1_1559_n101# dac_sub_r2r_2/m1_588_4371# m1_1922_419# VSUBS dac_sub_r2r_4/m1_1079_4371#
Xdac_sub_r2r_0 dac_sub_r2r_0/m1_588_4371# dac_sub_r2r_0/m1_127_199# dac_sub_r2r_0/m1_1079_4371#
+ dac_sub_r2r_0/m1_1559_n101# m1_1922_419# dac_sub_r2r_0/m1_120_4390# VSUBS dac_sub_r2r
Xdac_sub_r2r_1 dac_sub_r2r_1/m1_588_4371# m1_1922_419# dac_sub_r2r_1/m1_1079_4371#
+ dac_sub_r2r_1/m1_1559_n101# m1_5293_419# dac_sub_r2r_1/m1_120_4390# VSUBS dac_sub_r2r
Xdac_sub_r2r_2 dac_sub_r2r_2/m1_588_4371# m1_5293_419# dac_sub_r2r_2/m1_1079_4371#
+ dac_sub_r2r_2/m1_1559_n101# m1_7682_419# dac_sub_r2r_2/m1_120_4390# VSUBS dac_sub_r2r
Xdac_sub_r2r_3 dac_sub_r2r_3/m1_588_4371# m1_7682_419# dac_sub_r2r_3/m1_1079_4371#
+ dac_sub_r2r_3/m1_1559_n101# m1_10567_419# dac_sub_r2r_3/m1_120_4390# VSUBS dac_sub_r2r
Xdac_sub_r2r_4 dac_sub_r2r_4/m1_588_4371# m1_10567_419# dac_sub_r2r_4/m1_1079_4371#
+ dac_sub_r2r_4/m1_1559_n101# dac_sub_r2r_4/m1_2039_199# dac_sub_r2r_4/m1_120_4390#
+ VSUBS dac_sub_r2r
.ends

.subckt dac_5_3 B[0] B[1] B[2] B[3] B[4] T[0] T[1] T[2] T[3] T[4] T[5] T[6] DAC_5_3_OUT
+ GND
Xppolyf_u_1k_9VNAQZ_0 2R_0G|2R_01|2R_02|2R_0 2R_0G|2R_0G GND 2R_0G|2R_0G GND ppolyf_u_1k_9VNAQZ
Xdac_therm_3_bits_0 T[5] T[0] T[4] 2R_T3|2R_T3 2R_T5|2R_T5 T[6] 2R_T6|2R_T6 2R_T0|2R_T0
+ 2R_T4|2R_T4 2R_T2|2R_T2 DAC_5_3_OUT T[1] 2R_T1|2R_T1 T[2] T[3] GND dac_therm_3_bits
Xppolyf_u_1k_GR4QPH_0 GND GND GND GND GND GND GND ppolyf_u_1k_GR4QPH
Xdac_r2r_5_bits_0 2R_3|2R_3 B[2] 2R_2|2R2 DAC_5_3_OUT 2R_1|2R_1 2R_0G|2R_01|2R_02|2R_0
+ B[1] 2R_01|2R_01 2R_21|2R22|2R_31|2R_32|2R_3 2R_32|2R_32 B[0] 2R_41|2R_41 2R_22|2R22
+ B[4] 2R_31|2R_31 2R_42|2R_42 2R_02|2R_02 2R_11|2R_12|2R_21|2R_22|2R_2 2R_12|2R_12
+ 2R_11|2R_11 B[3] 2R_21|2R21 2R_01|2R_02|2R_11|2R_12|2R_1 GND 2R_4|2R_4 dac_r2r_5_bits
.ends
