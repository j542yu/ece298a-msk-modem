* NGSPICE file created from dac_5_3_parax.ext - technology: gf180mcuD

.subckt dac_5_3_parax B[0] B[1] B[2] B[3] B[4] T[0] T[1] T[2] T[3] T[4] T[5] T[6]
+ DAC_OUT VGND
X0 2R_2|2R2 B[2].t0 VGND.t22 ppolyf_u_1k r_width=2u r_length=20u
X1 2R_21|2R21 2R_21|2R22|2R_31|2R_32|2R_3 VGND.t14 ppolyf_u_1k r_width=2u r_length=20u
X2 2R_T5|2R_T5 DAC_OUT.t5 VGND.t35 ppolyf_u_1k r_width=2u r_length=20u
X3 2R_T4|2R_T4 DAC_OUT.t2 VGND.t23 ppolyf_u_1k r_width=2u r_length=20u
X4 2R_0|2R_0 B[0].t0 VGND.t26 ppolyf_u_1k r_width=2u r_length=20u
X5 2R_4|2R_4 2R_31|2R_32|2R_41|2R_42|2R_4 VGND.t36 ppolyf_u_1k r_width=2u r_length=20u
X6 2R_4|2R_4 B[4].t0 VGND.t16 ppolyf_u_1k r_width=2u r_length=20u
X7 2R_31|2R_31 2R_21|2R22|2R_31|2R_32|2R_3 VGND.t15 ppolyf_u_1k r_width=2u r_length=20u
X8 2R_3|2R_3 2R_21|2R22|2R_31|2R_32|2R_3 VGND.t2 ppolyf_u_1k r_width=2u r_length=20u
X9 2R_T4|2R_T4 T[4].t0 VGND.t13 ppolyf_u_1k r_width=2u r_length=20u
X10 2R_T5|2R_T5 T[5].t0 VGND.t28 ppolyf_u_1k r_width=2u r_length=20u
X11 2R_2|2R2 2R_11|2R_12|2R_21|2R_22|2R_2 VGND.t6 ppolyf_u_1k r_width=2u r_length=20u
X12 2R_T6|2R_T6 DAC_OUT.t3 VGND.t25 ppolyf_u_1k r_width=2u r_length=20u
X13 2R_42|2R_42 2R_31|2R_32|2R_41|2R_42|2R_4 VGND.t34 ppolyf_u_1k r_width=2u r_length=20u
X14 2R_41|2R_41 2R_31|2R_32|2R_41|2R_42|2R_4 VGND.t21 ppolyf_u_1k r_width=2u r_length=20u
X15 2R_11|2R_11 2R_01|2R_02|2R_11|2R_12|2R_1 VGND.t20 ppolyf_u_1k r_width=2u r_length=20u
X16 2R_1|2R_1 2R_01|2R_02|2R_11|2R_12|2R_1 VGND.t5 ppolyf_u_1k r_width=2u r_length=20u
X17 2R_T1|2R_T1 T[1].t0 VGND.t24 ppolyf_u_1k r_width=2u r_length=20u
X18 2R_21|2R21 2R_11|2R_12|2R_21|2R_22|2R_2 VGND.t12 ppolyf_u_1k r_width=2u r_length=20u
X19 2R_T2|2R_T2 T[2].t0 VGND.t1 ppolyf_u_1k r_width=2u r_length=20u
X20 2R_T0|2R_T0 DAC_OUT.t0 VGND.t4 ppolyf_u_1k r_width=2u r_length=20u
X21 2R_02|2R_02 2R_01|2R_02|2R_11|2R_12|2R_1 VGND.t0 ppolyf_u_1k r_width=2u r_length=20u
X22 2R_12|2R_12 2R_01|2R_02|2R_11|2R_12|2R_1 VGND.t11 ppolyf_u_1k r_width=2u r_length=20u
X23 2R_32|2R_32 2R_21|2R22|2R_31|2R_32|2R_3 VGND.t27 ppolyf_u_1k r_width=2u r_length=20u
X24 VGND.t54 VGND.t55 VGND.t53 ppolyf_u_1k r_width=2u r_length=20u
X25 2R_42|2R_42 DAC_OUT.t8 VGND.t52 ppolyf_u_1k r_width=2u r_length=20u
X26 VGND.t50 VGND.t51 VGND.t49 ppolyf_u_1k r_width=2u r_length=20u
X27 2R_12|2R_12 2R_11|2R_12|2R_21|2R_22|2R_2 VGND.t48 ppolyf_u_1k r_width=2u r_length=20u
X28 2R_32|2R_32 2R_31|2R_32|2R_41|2R_42|2R_4 VGND.t47 ppolyf_u_1k r_width=2u r_length=20u
X29 2R_T0|2R_T0 T[0].t0 VGND.t46 ppolyf_u_1k r_width=2u r_length=20u
X30 2R_T6|2R_T6 T[6].t0 VGND.t33 ppolyf_u_1k r_width=2u r_length=20u
X31 VGND.t44 VGND.t45 VGND.t43 ppolyf_u_1k r_width=2u r_length=20u
X32 2R_0G|2R_0G VGND.t42 VGND.t41 ppolyf_u_1k r_width=2u r_length=20u
X33 2R_22|2R22 2R_11|2R_12|2R_21|2R_22|2R_2 VGND.t32 ppolyf_u_1k r_width=2u r_length=20u
X34 2R_T2|2R_T2 DAC_OUT.t4 VGND.t31 ppolyf_u_1k r_width=2u r_length=20u
X35 2R_T1|2R_T1 DAC_OUT.t7 VGND.t40 ppolyf_u_1k r_width=2u r_length=20u
X36 2R_02|2R_02 2R_0G|2R_01|2R_02|2R_0 VGND.t39 ppolyf_u_1k r_width=2u r_length=20u
X37 2R_22|2R22 2R_21|2R22|2R_31|2R_32|2R_3 VGND.t29 ppolyf_u_1k r_width=2u r_length=20u
X38 2R_01|2R_01 2R_01|2R_02|2R_11|2R_12|2R_1 VGND.t30 ppolyf_u_1k r_width=2u r_length=20u
X39 2R_41|2R_41 DAC_OUT.t6 VGND.t38 ppolyf_u_1k r_width=2u r_length=20u
X40 2R_1|2R_1 B[1].t0 VGND.t37 ppolyf_u_1k r_width=2u r_length=20u
X41 2R_3|2R_3 B[3].t0 VGND.t18 ppolyf_u_1k r_width=2u r_length=20u
X42 2R_31|2R_31 2R_31|2R_32|2R_41|2R_42|2R_4 VGND.t17 ppolyf_u_1k r_width=2u r_length=20u
X43 2R_11|2R_11 2R_11|2R_12|2R_21|2R_22|2R_2 VGND.t10 ppolyf_u_1k r_width=2u r_length=20u
X44 2R_0G|2R_0G 2R_0G|2R_01|2R_02|2R_0 VGND.t3 ppolyf_u_1k r_width=2u r_length=20u
X45 2R_01|2R_01 2R_0G|2R_01|2R_02|2R_0 VGND.t19 ppolyf_u_1k r_width=2u r_length=20u
X46 2R_0|2R_0 2R_0G|2R_01|2R_02|2R_0 VGND.t7 ppolyf_u_1k r_width=2u r_length=20u
X47 2R_T3|2R_T3 T[3].t0 VGND.t9 ppolyf_u_1k r_width=2u r_length=20u
X48 2R_T3|2R_T3 DAC_OUT.t1 VGND.t8 ppolyf_u_1k r_width=2u r_length=20u
R0 B[2] B[2].t0 3.61864
R1 VGND.n5 VGND.n1 1787.75
R2 VGND.n5 VGND.n0 1785.72
R3 VGND.n3 VGND.n1 947.409
R4 VGND.n3 VGND.n0 945.409
R5 VGND.t47 VGND.t34 274.848
R6 VGND.t29 VGND.t27 274.848
R7 VGND.t33 VGND.t43 272.014
R8 VGND.t28 VGND.t33 272.014
R9 VGND.t13 VGND.t28 272.014
R10 VGND.t23 VGND.t13 272.014
R11 VGND.t35 VGND.t23 272.014
R12 VGND.t25 VGND.t35 272.014
R13 VGND.t4 VGND.t25 272.014
R14 VGND.t40 VGND.t4 272.014
R15 VGND.t31 VGND.t40 272.014
R16 VGND.t8 VGND.t31 272.014
R17 VGND.t9 VGND.t8 272.014
R18 VGND.t1 VGND.t9 272.014
R19 VGND.t24 VGND.t1 272.014
R20 VGND.t46 VGND.t24 272.014
R21 VGND.t38 VGND.t52 272.014
R22 VGND.t16 VGND.t38 272.014
R23 VGND.t36 VGND.t16 272.014
R24 VGND.t21 VGND.t36 272.014
R25 VGND.t34 VGND.t21 272.014
R26 VGND.t17 VGND.t47 272.014
R27 VGND.t18 VGND.t17 272.014
R28 VGND.t2 VGND.t18 272.014
R29 VGND.t15 VGND.t2 272.014
R30 VGND.t27 VGND.t15 272.014
R31 VGND.t14 VGND.t29 272.014
R32 VGND.t22 VGND.t14 272.014
R33 VGND.t6 VGND.t22 272.014
R34 VGND.t12 VGND.t6 272.014
R35 VGND.t32 VGND.t12 272.014
R36 VGND.t48 VGND.t32 272.014
R37 VGND.t10 VGND.t48 272.014
R38 VGND.t37 VGND.t10 272.014
R39 VGND.t5 VGND.t37 272.014
R40 VGND.t20 VGND.t5 272.014
R41 VGND.t11 VGND.t20 272.014
R42 VGND.t0 VGND.t11 272.014
R43 VGND.t30 VGND.t0 272.014
R44 VGND.t26 VGND.t30 272.014
R45 VGND.t7 VGND.t26 272.014
R46 VGND.t19 VGND.t7 272.014
R47 VGND.t39 VGND.t19 272.014
R48 VGND.t3 VGND.t39 272.014
R49 VGND.t41 VGND.t3 272.014
R50 VGND.t53 VGND.t41 272.014
R51 VGND.n4 VGND.t46 269.748
R52 VGND.t52 VGND.t49 266.348
R53 VGND.t43 VGND.n3 213.189
R54 VGND.n5 VGND.t53 213.189
R55 VGND.n2 VGND.t44 8.34196
R56 VGND.n2 VGND.t45 8.34196
R57 VGND.n6 VGND.t54 8.34196
R58 VGND.n0 VGND.t50 5.30442
R59 VGND.n1 VGND.t51 4.87122
R60 VGND.n7 VGND.t42 4.50913
R61 VGND.n8 VGND.n6 3.8705
R62 VGND.n7 VGND.t55 3.57
R63 VGND.t49 VGND.n4 2.26728
R64 VGND.n4 VGND.n0 1.73383
R65 VGND.n4 VGND.n1 1.3005
R66 VGND.n8 VGND.n7 0.700561
R67 VGND VGND.n8 0.475045
R68 VGND.n3 VGND.n2 0.111138
R69 VGND.n6 VGND.n5 0.111138
R70 DAC_OUT.n0 DAC_OUT.t2 4.50913
R71 DAC_OUT.n8 DAC_OUT.t8 3.62004
R72 DAC_OUT DAC_OUT.t1 3.58655
R73 DAC_OUT.n5 DAC_OUT.t4 3.57
R74 DAC_OUT.n3 DAC_OUT.t7 3.57
R75 DAC_OUT.n2 DAC_OUT.t0 3.57
R76 DAC_OUT.n1 DAC_OUT.t3 3.57
R77 DAC_OUT.n0 DAC_OUT.t5 3.57
R78 DAC_OUT.n9 DAC_OUT.t6 3.57
R79 DAC_OUT.n4 DAC_OUT 1.13724
R80 DAC_OUT.n1 DAC_OUT.n0 0.93963
R81 DAC_OUT.n3 DAC_OUT.n2 0.93963
R82 DAC_OUT.n8 DAC_OUT.n7 0.862496
R83 DAC_OUT.n4 DAC_OUT.n3 0.581587
R84 DAC_OUT.n2 DAC_OUT 0.573761
R85 DAC_OUT DAC_OUT.n1 0.36637
R86 DAC_OUT.n7 DAC_OUT 0.240307
R87 DAC_OUT.n7 DAC_OUT.n6 0.188
R88 DAC_OUT.n6 DAC_OUT.n5 0.0493341
R89 DAC_OUT.n9 DAC_OUT.n8 0.0473161
R90 DAC_OUT DAC_OUT.n9 0.0382354
R91 DAC_OUT.n5 DAC_OUT.n4 0.0374282
R92 DAC_OUT.n6 DAC_OUT 0.0319798
R93 B[0] B[0].t0 3.61864
R94 B[4] B[4].t0 3.61864
R95 T[4] T[4].t0 3.59605
R96 T[5] T[5].t0 3.59605
R97 T[1] T[1].t0 3.59605
R98 T[2] T[2].t0 3.59605
R99 T[0] T[0].t0 3.59605
R100 T[6] T[6].t0 3.59605
R101 B[1] B[1].t0 3.61864
R102 B[3] B[3].t0 3.61864
R103 T[3] T[3].t0 3.59605
C0 2R_11|2R_11 2R_2|2R2 0
C1 B[3] 2R_21|2R22|2R_31|2R_32|2R_3 0.04645f
C2 2R_02|2R_02 2R_0G|2R_0G 0.04634f
C3 2R_42|2R_42 2R_32|2R_32 0.14633f
C4 T[4] DAC_OUT 0.04699f
C5 B[4] DAC_OUT 0.22873f
C6 2R_T1|2R_T1 2R_T4|2R_T4 0
C7 2R_32|2R_32 2R_22|2R22 0.14633f
C8 2R_T1|2R_T1 2R_T3|2R_T3 0.00473f
C9 2R_0|2R_0 2R_01|2R_01 0.92631f
C10 2R_T1|2R_T1 2R_T0|2R_T0 1.71136f
C11 2R_31|2R_31 2R_32|2R_32 1.73284f
C12 2R_4|2R_4 2R_41|2R_41 0.92631f
C13 2R_12|2R_12 2R_22|2R22 0.15439f
C14 T[2] T[3] 0.29805f
C15 2R_11|2R_12|2R_21|2R_22|2R_2 B[2] 0.04645f
C16 T[6] T[5] 0.29805f
C17 2R_02|2R_02 2R_12|2R_12 0.15439f
C18 2R_11|2R_11 2R_21|2R21 0
C19 2R_11|2R_12|2R_21|2R_22|2R_2 2R_01|2R_02|2R_11|2R_12|2R_1 0
C20 2R_T3|2R_T3 2R_T2|2R_T2 0.35649f
C21 2R_11|2R_12|2R_21|2R_22|2R_2 B[1] 0.04647f
C22 2R_T0|2R_T0 2R_T2|2R_T2 0.0023f
C23 2R_01|2R_02|2R_11|2R_12|2R_1 B[1] 0.04645f
C24 2R_T0|2R_T0 2R_41|2R_41 0
C25 2R_T6|2R_T6 2R_T5|2R_T5 1.05132f
C26 2R_11|2R_11 2R_22|2R22 0
C27 DAC_OUT T[1] 0.35044f
C28 B[3] 2R_31|2R_32|2R_41|2R_42|2R_4 0.04647f
C29 2R_02|2R_02 2R_01|2R_01 1.73284f
C30 2R_21|2R21 2R_2|2R2 0.92631f
C31 2R_3|2R_3 2R_21|2R21 0
C32 T[0] DAC_OUT 0.37068f
C33 2R_42|2R_42 2R_41|2R_41 1.73284f
C34 2R_42|2R_42 2R_4|2R_4 0.00831f
C35 DAC_OUT 2R_31|2R_32|2R_41|2R_42|2R_4 0.0025f
C36 T[2] DAC_OUT 0.3506f
C37 2R_0G|2R_01|2R_02|2R_0 2R_01|2R_02|2R_11|2R_12|2R_1 0
C38 2R_T6|2R_T6 2R_T1|2R_T1 0
C39 2R_T3|2R_T3 2R_T0|2R_T0 0.00231f
C40 2R_22|2R22 2R_2|2R2 0.00831f
C41 2R_31|2R_31 2R_41|2R_41 0
C42 T[3] DAC_OUT 0.5667f
C43 2R_4|2R_4 2R_31|2R_31 0
C44 2R_3|2R_3 2R_31|2R_31 0.92631f
C45 2R_12|2R_12 2R_01|2R_01 0
C46 2R_T1|2R_T1 2R_T5|2R_T5 0
C47 2R_11|2R_11 2R_12|2R_12 1.73284f
C48 B[4] 2R_31|2R_32|2R_41|2R_42|2R_4 0.04645f
C49 2R_21|2R22|2R_31|2R_32|2R_3 2R_31|2R_32|2R_41|2R_42|2R_4 0
C50 2R_12|2R_12 2R_1|2R_1 0.00831f
C51 B[2] 2R_21|2R22|2R_31|2R_32|2R_3 0.04647f
C52 2R_01|2R_02|2R_11|2R_12|2R_1 B[0] 0.04647f
C53 2R_02|2R_02 2R_0|2R_0 0.00831f
C54 2R_21|2R21 2R_22|2R22 1.73284f
C55 2R_3|2R_3 2R_32|2R_32 0.00831f
C56 2R_31|2R_31 2R_21|2R21 0
C57 2R_11|2R_11 2R_01|2R_01 0
C58 T[4] T[5] 0.29805f
C59 2R_11|2R_12|2R_21|2R_22|2R_2 2R_21|2R22|2R_31|2R_32|2R_3 0
C60 2R_42|2R_42 2R_31|2R_31 0
C61 2R_T6|2R_T6 2R_T4|2R_T4 0.00734f
C62 2R_01|2R_01 2R_1|2R_1 0
C63 2R_T6|2R_T6 2R_T0|2R_T0 0.18829f
C64 2R_T1|2R_T1 2R_T2|2R_T2 1.15162f
C65 2R_11|2R_11 2R_1|2R_1 0.92631f
C66 T[0] T[1] 0.29805f
C67 2R_T1|2R_T1 2R_41|2R_41 0
C68 2R_0G|2R_01|2R_02|2R_0 B[0] 0.04645f
C69 T[2] T[1] 0.29805f
C70 2R_32|2R_32 2R_21|2R21 0
C71 2R_T5|2R_T5 2R_T4|2R_T4 0.9263f
C72 T[6] VGND 0.87291f
C73 T[5] VGND 0.73119f
C74 T[4] VGND 0.8262f
C75 T[3] VGND 0.76306f
C76 T[2] VGND 0.73119f
C77 T[1] VGND 0.73119f
C78 T[0] VGND 0.93798f
C79 DAC_OUT VGND 8.26364f
C80 B[4] VGND 0.67242f
C81 B[3] VGND 0.72074f
C82 B[2] VGND 0.72073f
C83 B[1] VGND 0.72073f
C84 B[0] VGND 0.72073f
C85 2R_T4|2R_T4 VGND 0.92687f
C86 2R_T5|2R_T5 VGND 1.18371f
C87 2R_T6|2R_T6 VGND 2.05995f
C88 2R_T3|2R_T3 VGND 0.95623f
C89 2R_T2|2R_T2 VGND 1.31238f
C90 2R_T1|2R_T1 VGND 1.57743f
C91 2R_T0|2R_T0 VGND 2.7392f
C92 2R_4|2R_4 VGND 0.92678f
C93 2R_41|2R_41 VGND 1.13007f
C94 2R_42|2R_42 VGND 2.01152f
C95 2R_31|2R_32|2R_41|2R_42|2R_4 VGND 2.75137f
C96 2R_3|2R_3 VGND 0.92678f
C97 2R_31|2R_31 VGND 1.13005f
C98 2R_32|2R_32 VGND 1.84021f
C99 2R_21|2R22|2R_31|2R_32|2R_3 VGND 2.75137f
C100 2R_2|2R2 VGND 0.92678f
C101 2R_21|2R21 VGND 1.13005f
C102 2R_22|2R22 VGND 1.83907f
C103 2R_11|2R_12|2R_21|2R_22|2R_2 VGND 2.74802f
C104 2R_1|2R_1 VGND 0.92678f
C105 2R_11|2R_11 VGND 1.13005f
C106 2R_12|2R_12 VGND 1.83793f
C107 2R_01|2R_02|2R_11|2R_12|2R_1 VGND 2.74802f
C108 2R_0|2R_0 VGND 0.92678f
C109 2R_01|2R_01 VGND 1.13005f
C110 2R_02|2R_02 VGND 1.8805f
C111 2R_0G|2R_01|2R_02|2R_0 VGND 2.24304f
C112 2R_0G|2R_0G VGND 1.12723f
.ends
